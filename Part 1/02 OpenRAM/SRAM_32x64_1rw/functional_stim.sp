* Functional test stimulus file for 5ns period

* TT process corner
.include "/home/ali/OpenRAM/technology/freepdk45/models/tran_models/models_nom/PMOS_VTG.inc"
.include "/home/ali/OpenRAM/technology/freepdk45/models/tran_models/models_nom/NMOS_VTG.inc"
.include "/tmp/openram_ali_38549_temp/sram.sp"

* Global Power Supplies
Vvdd vdd 0 1.1

*Nodes gnd and 0 are the same global ground node in ngspice/hspice/xa. Otherwise, this source may be needed.
*Vgnd gnd 0 0.0

* Instantiation of the SRAM
XSRAM_32x64_1rw din0_0 din0_1 din0_2 din0_3 din0_4 din0_5 din0_6 din0_7 din0_8 din0_9 din0_10 din0_11 din0_12 din0_13 din0_14 din0_15 din0_16 din0_17 din0_18 din0_19 din0_20 din0_21 din0_22 din0_23 din0_24 din0_25 din0_26 din0_27 din0_28 din0_29 din0_30 din0_31 a0_0 a0_1 a0_2 a0_3 a0_4 a0_5 CSB0 WEB0 clk0 dout0_0 dout0_1 dout0_2 dout0_3 dout0_4 dout0_5 dout0_6 dout0_7 dout0_8 dout0_9 dout0_10 dout0_11 dout0_12 dout0_13 dout0_14 dout0_15 dout0_16 dout0_17 dout0_18 dout0_19 dout0_20 dout0_21 dout0_22 dout0_23 dout0_24 dout0_25 dout0_26 dout0_27 dout0_28 dout0_29 dout0_30 dout0_31 vdd gnd SRAM_32x64_1rw

* SRAM output loads
CD00 dout0_0  0 0.8364f
CD01 dout0_1  0 0.8364f
CD02 dout0_2  0 0.8364f
CD03 dout0_3  0 0.8364f
CD04 dout0_4  0 0.8364f
CD05 dout0_5  0 0.8364f
CD06 dout0_6  0 0.8364f
CD07 dout0_7  0 0.8364f
CD08 dout0_8  0 0.8364f
CD09 dout0_9  0 0.8364f
CD010 dout0_10  0 0.8364f
CD011 dout0_11  0 0.8364f
CD012 dout0_12  0 0.8364f
CD013 dout0_13  0 0.8364f
CD014 dout0_14  0 0.8364f
CD015 dout0_15  0 0.8364f
CD016 dout0_16  0 0.8364f
CD017 dout0_17  0 0.8364f
CD018 dout0_18  0 0.8364f
CD019 dout0_19  0 0.8364f
CD020 dout0_20  0 0.8364f
CD021 dout0_21  0 0.8364f
CD022 dout0_22  0 0.8364f
CD023 dout0_23  0 0.8364f
CD024 dout0_24  0 0.8364f
CD025 dout0_25  0 0.8364f
CD026 dout0_26  0 0.8364f
CD027 dout0_27  0 0.8364f
CD028 dout0_28  0 0.8364f
CD029 dout0_29  0 0.8364f
CD030 dout0_30  0 0.8364f
CD031 dout0_31  0 0.8364f

* Important signals for debug
* bl:	xsram:xbank0:bl_0_0
* br:	xsram:xbank0:br_0_0
* s_en:	xsram:s_en
* q:	xsram:xbank0:xbitcell_array:xbitcell_array:xbit_r0_c0.Q
* qbar:	xsram:xbank0:xbitcell_array:xbitcell_array:xbit_r0_c0.Q_bar

* Sequence of operations
*	Idle during cycle 0 (0ns - 5ns)
*	Writing 11011001111101101100101011101000  to  address 111101 (from port 0) during cycle 1 (5ns - 10ns)
*	Writing 01000001111100111010111011100000  to  address 111110 (from port 0) during cycle 2 (10ns - 15ns)
*	Writing 10111001100101111000111010100100  to  address 000001 (from port 0) during cycle 3 (15ns - 20ns)
*	Reading 11011001111101101100101011101000 from address 111101 (from port 0) during cycle 4 (20ns - 25ns)
*	Reading 01000001111100111010111011100000 from address 111110 (from port 0) during cycle 5 (25ns - 30ns)
*	Writing 11000111011010110111000100101011  to  address 000011 (from port 0) during cycle 6 (30ns - 35ns)
*	Writing 11111111111101110110101111110111  to  address 000010 (from port 0) during cycle 7 (35ns - 40ns)
*	Reading 11111111111101110110101111110111 from address 000010 (from port 0) during cycle 9 (45ns - 50ns)
*	Reading 10111001100101111000111010100100 from address 000001 (from port 0) during cycle 10 (50ns - 55ns)
*	Reading 11000111011010110111000100101011 from address 000011 (from port 0) during cycle 11 (55ns - 60ns)
*	Writing 10000110110011010011100101111000  to  address 000000 (from port 0) during cycle 12 (60ns - 65ns)
*	Writing 00100001000010001100001100011000  to  address 111110 (from port 0) during cycle 13 (65ns - 70ns)
*	Writing 00000010001010101110100101011101  to  address 111100 (from port 0) during cycle 16 (80ns - 85ns)
*	Reading 10111001100101111000111010100100 from address 000001 (from port 0) during cycle 18 (90ns - 95ns)
*	Writing 01001000011001000011000000101011  to  address 111100 (from port 0) during cycle 19 (95ns - 100ns)
*	Reading 10000110110011010011100101111000 from address 000000 (from port 0) during cycle 20 (100ns - 105ns)
*	Writing 01101010111011010010110110111011  to  address 000000 (from port 0) during cycle 22 (110ns - 115ns)
*	Writing 01000000010011101010101010111110  to  address 111101 (from port 0) during cycle 23 (115ns - 120ns)
*	Reading 01101010111011010010110110111011 from address 000000 (from port 0) during cycle 24 (120ns - 125ns)
*	Reading 01101010111011010010110110111011 from address 000000 (from port 0) during cycle 25 (125ns - 130ns)
*	Writing 00110110110110111110111100100111  to  address 000011 (from port 0) during cycle 26 (130ns - 135ns)
*	Writing 11000001101110101100101100100011  to  address 000000 (from port 0) during cycle 27 (135ns - 140ns)
*	Writing 01111111101100010011001111001100  to  address 111100 (from port 0) during cycle 28 (140ns - 145ns)
*	Reading 00110110110110111110111100100111 from address 000011 (from port 0) during cycle 29 (145ns - 150ns)
*	Writing 01110111111010011110010000001111  to  address 111100 (from port 0) during cycle 30 (150ns - 155ns)
*	Writing 10000111000001011011101001101111  to  address 000001 (from port 0) during cycle 31 (155ns - 160ns)
*	Reading 10000111000001011011101001101111 from address 000001 (from port 0) during cycle 32 (160ns - 165ns)
*	Reading 00100001000010001100001100011000 from address 111110 (from port 0) during cycle 33 (165ns - 170ns)
*	Reading 00100001000010001100001100011000 from address 111110 (from port 0) during cycle 34 (170ns - 175ns)
*	Reading 00100001000010001100001100011000 from address 111110 (from port 0) during cycle 35 (175ns - 180ns)
*	Reading 00100001000010001100001100011000 from address 111110 (from port 0) during cycle 36 (180ns - 185ns)
*	Reading 11111111111101110110101111110111 from address 000010 (from port 0) during cycle 37 (185ns - 190ns)
*	Reading 00100001000010001100001100011000 from address 111110 (from port 0) during cycle 38 (190ns - 195ns)
*	Reading 11111111111101110110101111110111 from address 000010 (from port 0) during cycle 39 (195ns - 200ns)
*	Reading 01000000010011101010101010111110 from address 111101 (from port 0) during cycle 40 (200ns - 205ns)
*	Reading 10000111000001011011101001101111 from address 000001 (from port 0) during cycle 41 (205ns - 210ns)
*	Reading 11000001101110101100101100100011 from address 000000 (from port 0) during cycle 43 (215ns - 220ns)
*	Reading 01110111111010011110010000001111 from address 111100 (from port 0) during cycle 44 (220ns - 225ns)
*	Writing 10011001101110010001100101011100  to  address 111011 (from port 0) during cycle 45 (225ns - 230ns)
*	Reading 11111111111101110110101111110111 from address 000010 (from port 0) during cycle 46 (230ns - 235ns)
*	Reading 11111111111101110110101111110111 from address 000010 (from port 0) during cycle 48 (240ns - 245ns)
*	Reading 00100001000010001100001100011000 from address 111110 (from port 0) during cycle 50 (250ns - 255ns)
*	Reading 01000000010011101010101010111110 from address 111101 (from port 0) during cycle 51 (255ns - 260ns)
*	Writing 01001111011110110011101011001100  to  address 000001 (from port 0) during cycle 53 (265ns - 270ns)
*	Writing 11101100000100101100110101001111  to  address 111110 (from port 0) during cycle 54 (270ns - 275ns)
*	Reading 01110111111010011110010000001111 from address 111100 (from port 0) during cycle 55 (275ns - 280ns)
*	Reading 01001111011110110011101011001100 from address 000001 (from port 0) during cycle 56 (280ns - 285ns)
*	Reading 01001111011110110011101011001100 from address 000001 (from port 0) during cycle 57 (285ns - 290ns)
*	Reading 01110111111010011110010000001111 from address 111100 (from port 0) during cycle 58 (290ns - 295ns)
*	Reading 01000000010011101010101010111110 from address 111101 (from port 0) during cycle 60 (300ns - 305ns)
*	Reading 11000001101110101100101100100011 from address 000000 (from port 0) during cycle 61 (305ns - 310ns)
*	Reading 00110110110110111110111100100111 from address 000011 (from port 0) during cycle 63 (315ns - 320ns)
*	Reading 01001111011110110011101011001100 from address 000001 (from port 0) during cycle 64 (320ns - 325ns)
*	Reading 11101100000100101100110101001111 from address 111110 (from port 0) during cycle 66 (330ns - 335ns)
*	Reading 00110110110110111110111100100111 from address 000011 (from port 0) during cycle 68 (340ns - 345ns)
*	Reading 01110111111010011110010000001111 from address 111100 (from port 0) during cycle 69 (345ns - 350ns)
*	Writing 01011111110011011101100101010001  to  address 000011 (from port 0) during cycle 71 (355ns - 360ns)
*	Reading 10011001101110010001100101011100 from address 111011 (from port 0) during cycle 72 (360ns - 365ns)
*	Reading 01000000010011101010101010111110 from address 111101 (from port 0) during cycle 74 (370ns - 375ns)
*	Reading 11000001101110101100101100100011 from address 000000 (from port 0) during cycle 75 (375ns - 380ns)
*	Writing 00101000011000010110010101110000  to  address 000011 (from port 0) during cycle 76 (380ns - 385ns)
*	Reading 01110111111010011110010000001111 from address 111100 (from port 0) during cycle 77 (385ns - 390ns)
*	Reading 10011001101110010001100101011100 from address 111011 (from port 0) during cycle 78 (390ns - 395ns)
*	Reading 01001111011110110011101011001100 from address 000001 (from port 0) during cycle 80 (400ns - 405ns)
*	Reading 11101100000100101100110101001111 from address 111110 (from port 0) during cycle 82 (410ns - 415ns)
*	Reading 11111111111101110110101111110111 from address 000010 (from port 0) during cycle 83 (415ns - 420ns)
*	Writing 00000010011110110100000110110100  to  address 111100 (from port 0) during cycle 84 (420ns - 425ns)
*	Reading 00000010011110110100000110110100 from address 111100 (from port 0) during cycle 85 (425ns - 430ns)
*	Reading 10011001101110010001100101011100 from address 111011 (from port 0) during cycle 86 (430ns - 435ns)
*	Reading 11101100000100101100110101001111 from address 111110 (from port 0) during cycle 87 (435ns - 440ns)
*	Reading 11101100000100101100110101001111 from address 111110 (from port 0) during cycle 89 (445ns - 450ns)
*	Reading 11101100000100101100110101001111 from address 111110 (from port 0) during cycle 90 (450ns - 455ns)
*	Reading 10011001101110010001100101011100 from address 111011 (from port 0) during cycle 91 (455ns - 460ns)
*	Reading 00000010011110110100000110110100 from address 111100 (from port 0) during cycle 93 (465ns - 470ns)
*	Writing 10110011000111111110110101100001  to  address 000001 (from port 0) during cycle 94 (470ns - 475ns)
*	Writing 11000100100010010010011001001100  to  address 111101 (from port 0) during cycle 95 (475ns - 480ns)
*	Reading 11000100100010010010011001001100 from address 111101 (from port 0) during cycle 96 (480ns - 485ns)
*	Reading 11111111111101110110101111110111 from address 000010 (from port 0) during cycle 98 (490ns - 495ns)
*	Writing 01111000101001110011001100000000  to  address 000010 (from port 0) during cycle 99 (495ns - 500ns)
*	Reading 00000010011110110100000110110100 from address 111100 (from port 0) during cycle 101 (505ns - 510ns)
*	Reading 10110011000111111110110101100001 from address 000001 (from port 0) during cycle 102 (510ns - 515ns)
*	Writing 11010111111100100100011011001111  to  address 111100 (from port 0) during cycle 104 (520ns - 525ns)
*	Writing 11001110000101100100110000111110  to  address 111100 (from port 0) during cycle 105 (525ns - 530ns)
*	Reading 10110011000111111110110101100001 from address 000001 (from port 0) during cycle 106 (530ns - 535ns)
*	Writing 10100000111111100101001000111011  to  address 111011 (from port 0) during cycle 107 (535ns - 540ns)
*	Reading 10100000111111100101001000111011 from address 111011 (from port 0) during cycle 108 (540ns - 545ns)
*	Reading 11000100100010010010011001001100 from address 111101 (from port 0) during cycle 109 (545ns - 550ns)
*	Reading 00101000011000010110010101110000 from address 000011 (from port 0) during cycle 110 (550ns - 555ns)
*	Reading 11101100000100101100110101001111 from address 111110 (from port 0) during cycle 111 (555ns - 560ns)
*	Reading 10100000111111100101001000111011 from address 111011 (from port 0) during cycle 112 (560ns - 565ns)
*	Reading 01111000101001110011001100000000 from address 000010 (from port 0) during cycle 113 (565ns - 570ns)
*	Reading 11101100000100101100110101001111 from address 111110 (from port 0) during cycle 114 (570ns - 575ns)
*	Reading 11001110000101100100110000111110 from address 111100 (from port 0) during cycle 115 (575ns - 580ns)
*	Reading 11001110000101100100110000111110 from address 111100 (from port 0) during cycle 116 (580ns - 585ns)
*	Reading 11000001101110101100101100100011 from address 000000 (from port 0) during cycle 117 (585ns - 590ns)
*	Reading 11000100100010010010011001001100 from address 111101 (from port 0) during cycle 118 (590ns - 595ns)
*	Reading 11000100100010010010011001001100 from address 111101 (from port 0) during cycle 121 (605ns - 610ns)
*	Writing 11111110000011010000000111100010  to  address 000011 (from port 0) during cycle 124 (620ns - 625ns)
*	Reading 11101100000100101100110101001111 from address 111110 (from port 0) during cycle 125 (625ns - 630ns)
*	Reading 10100000111111100101001000111011 from address 111011 (from port 0) during cycle 128 (640ns - 645ns)
*	Writing 10010111000001101101001100110100  to  address 000010 (from port 0) during cycle 129 (645ns - 650ns)
*	Reading 11000100100010010010011001001100 from address 111101 (from port 0) during cycle 130 (650ns - 655ns)
*	Reading 11000001101110101100101100100011 from address 000000 (from port 0) during cycle 131 (655ns - 660ns)
*	Writing 00111101111111001010100011011111  to  address 000011 (from port 0) during cycle 132 (660ns - 665ns)
*	Writing 10101001110111011011010010001010  to  address 000001 (from port 0) during cycle 133 (665ns - 670ns)
*	Reading 11000001101110101100101100100011 from address 000000 (from port 0) during cycle 134 (670ns - 675ns)
*	Writing 11110001101011011101000111100100  to  address 000010 (from port 0) during cycle 135 (675ns - 680ns)
*	Writing 00000011010000111100100010011000  to  address 111100 (from port 0) during cycle 136 (680ns - 685ns)
*	Reading 10101001110111011011010010001010 from address 000001 (from port 0) during cycle 137 (685ns - 690ns)
*	Reading 00111101111111001010100011011111 from address 000011 (from port 0) during cycle 138 (690ns - 695ns)
*	Reading 11110001101011011101000111100100 from address 000010 (from port 0) during cycle 139 (695ns - 700ns)
*	Reading 11110001101011011101000111100100 from address 000010 (from port 0) during cycle 141 (705ns - 710ns)
*	Writing 00110010101011101111111110000001  to  address 000001 (from port 0) during cycle 142 (710ns - 715ns)
*	Writing 00000101110111110010011010010100  to  address 111110 (from port 0) during cycle 143 (715ns - 720ns)
*	Reading 10100000111111100101001000111011 from address 111011 (from port 0) during cycle 144 (720ns - 725ns)
*	Reading 11000001101110101100101100100011 from address 000000 (from port 0) during cycle 146 (730ns - 735ns)
*	Reading 00000011010000111100100010011000 from address 111100 (from port 0) during cycle 147 (735ns - 740ns)
*	Writing 00011111010011011101101100011110  to  address 111011 (from port 0) during cycle 148 (740ns - 745ns)
*	Reading 00011111010011011101101100011110 from address 111011 (from port 0) during cycle 149 (745ns - 750ns)
*	Reading 00110010101011101111111110000001 from address 000001 (from port 0) during cycle 151 (755ns - 760ns)
*	Writing 10011111001010100110111000100101  to  address 111101 (from port 0) during cycle 152 (760ns - 765ns)
*	Reading 00011111010011011101101100011110 from address 111011 (from port 0) during cycle 153 (765ns - 770ns)
*	Writing 10110100110101101111001111001100  to  address 111100 (from port 0) during cycle 154 (770ns - 775ns)
*	Reading 00111101111111001010100011011111 from address 000011 (from port 0) during cycle 155 (775ns - 780ns)
*	Writing 00111111111010011001011011111001  to  address 000000 (from port 0) during cycle 157 (785ns - 790ns)
*	Writing 00000000111011111110011111101101  to  address 000011 (from port 0) during cycle 158 (790ns - 795ns)
*	Writing 00100111011010001011100001100110  to  address 000010 (from port 0) during cycle 159 (795ns - 800ns)
*	Reading 00100111011010001011100001100110 from address 000010 (from port 0) during cycle 160 (800ns - 805ns)
*	Reading 00011111010011011101101100011110 from address 111011 (from port 0) during cycle 161 (805ns - 810ns)
*	Reading 00100111011010001011100001100110 from address 000010 (from port 0) during cycle 162 (810ns - 815ns)
*	Reading 00110010101011101111111110000001 from address 000001 (from port 0) during cycle 164 (820ns - 825ns)
*	Reading 00110010101011101111111110000001 from address 000001 (from port 0) during cycle 165 (825ns - 830ns)
*	Reading 00100111011010001011100001100110 from address 000010 (from port 0) during cycle 166 (830ns - 835ns)
*	Reading 00000000111011111110011111101101 from address 000011 (from port 0) during cycle 167 (835ns - 840ns)
*	Writing 11010110010001101001000000001111  to  address 000001 (from port 0) during cycle 169 (845ns - 850ns)
*	Reading 10110100110101101111001111001100 from address 111100 (from port 0) during cycle 170 (850ns - 855ns)
*	Reading 10011111001010100110111000100101 from address 111101 (from port 0) during cycle 171 (855ns - 860ns)
*	Writing 11010100110110111001111111001101  to  address 111011 (from port 0) during cycle 172 (860ns - 865ns)
*	Writing 01011100000101101111001111110000  to  address 000001 (from port 0) during cycle 173 (865ns - 870ns)
*	Writing 01011110110100100010000110100101  to  address 111101 (from port 0) during cycle 175 (875ns - 880ns)
*	Reading 10110100110101101111001111001100 from address 111100 (from port 0) during cycle 177 (885ns - 890ns)
*	Writing 11100101111011110101011001110111  to  address 111100 (from port 0) during cycle 178 (890ns - 895ns)
*	Reading 00100111011010001011100001100110 from address 000010 (from port 0) during cycle 179 (895ns - 900ns)
*	Writing 01000111011100001001110100101000  to  address 111011 (from port 0) during cycle 180 (900ns - 905ns)
*	Writing 01011000000100110100010110000001  to  address 111110 (from port 0) during cycle 182 (910ns - 915ns)
*	Reading 01011100000101101111001111110000 from address 000001 (from port 0) during cycle 184 (920ns - 925ns)
*	Reading 01000111011100001001110100101000 from address 111011 (from port 0) during cycle 186 (930ns - 935ns)
*	Reading 01011110110100100010000110100101 from address 111101 (from port 0) during cycle 187 (935ns - 940ns)
*	Reading 01000111011100001001110100101000 from address 111011 (from port 0) during cycle 188 (940ns - 945ns)
*	Reading 00111111111010011001011011111001 from address 000000 (from port 0) during cycle 192 (960ns - 965ns)
*	Reading 01011100000101101111001111110000 from address 000001 (from port 0) during cycle 193 (965ns - 970ns)
*	Writing 01111000111000110000100100010100  to  address 111100 (from port 0) during cycle 195 (975ns - 980ns)
*	Writing 10010111100010100010001001110100  to  address 111110 (from port 0) during cycle 199 (995ns - 1000ns)
*	Writing 01100000100010001100010111110100  to  address 111110 (from port 0) during cycle 201 (1005ns - 1010ns)
*	Reading 01100000100010001100010111110100 from address 111110 (from port 0) during cycle 202 (1010ns - 1015ns)
*	Reading 01011100000101101111001111110000 from address 000001 (from port 0) during cycle 204 (1020ns - 1025ns)
*	Idle during cycle 205 (1025ns - 1030ns)

* Generation of data and address signals
* (time, data): [(0, 0), (5, 0), (10, 0), (15, 0), (20, 0), (25, 0), (30, 1), (35, 1), (40, 1), (45, 1), (50, 1), (55, 1), (60, 0), (65, 0), (70, 0), (75, 0), (80, 1), (85, 1), (90, 1), (95, 1), (100, 1), (105, 1), (110, 1), (115, 0), (120, 0), (125, 0), (130, 1), (135, 1), (140, 0), (145, 0), (150, 1), (155, 1), (160, 1), (165, 1), (170, 1), (175, 1), (180, 1), (185, 1), (190, 1), (195, 1), (200, 1), (205, 1), (210, 1), (215, 1), (220, 1), (225, 0), (230, 0), (235, 0), (240, 0), (245, 0), (250, 0), (255, 0), (260, 0), (265, 0), (270, 1), (275, 1), (280, 1), (285, 1), (290, 1), (295, 1), (300, 1), (305, 1), (310, 1), (315, 1), (320, 1), (325, 1), (330, 1), (335, 1), (340, 1), (345, 1), (350, 1), (355, 1), (360, 1), (365, 1), (370, 1), (375, 1), (380, 0), (385, 0), (390, 0), (395, 0), (400, 0), (405, 0), (410, 0), (415, 0), (420, 0), (425, 0), (430, 0), (435, 0), (440, 0), (445, 0), (450, 0), (455, 0), (460, 0), (465, 0), (470, 1), (475, 0), (480, 0), (485, 0), (490, 0), (495, 0), (500, 0), (505, 0), (510, 0), (515, 0), (520, 1), (525, 0), (530, 0), (535, 1), (540, 1), (545, 1), (550, 1), (555, 1), (560, 1), (565, 1), (570, 1), (575, 1), (580, 1), (585, 1), (590, 1), (595, 1), (600, 1), (605, 1), (610, 1), (615, 1), (620, 0), (625, 0), (630, 0), (635, 0), (640, 0), (645, 0), (650, 0), (655, 0), (660, 1), (665, 0), (670, 0), (675, 0), (680, 0), (685, 0), (690, 0), (695, 0), (700, 0), (705, 0), (710, 1), (715, 0), (720, 0), (725, 0), (730, 0), (735, 0), (740, 0), (745, 0), (750, 0), (755, 0), (760, 1), (765, 1), (770, 0), (775, 0), (780, 0), (785, 1), (790, 1), (795, 0), (800, 0), (805, 0), (810, 0), (815, 0), (820, 0), (825, 0), (830, 0), (835, 0), (840, 0), (845, 1), (850, 1), (855, 1), (860, 1), (865, 0), (870, 0), (875, 1), (880, 1), (885, 1), (890, 1), (895, 1), (900, 0), (905, 0), (910, 1), (915, 1), (920, 1), (925, 1), (930, 1), (935, 1), (940, 1), (945, 1), (950, 1), (955, 1), (960, 1), (965, 1), (970, 1), (975, 0), (980, 0), (985, 0), (990, 0), (995, 0), (1000, 0), (1005, 0), (1010, 0), (1015, 0), (1020, 0), (1025, 0)]
Vdin0_0  din0_0  0 PWL (0n 0.0v 4.745n 0.0v 4.755n 0.0v 9.745n 0.0v 9.755n 0.0v 14.745n 0.0v 14.755n 0.0v 19.745n 0.0v 19.755n 0.0v 24.745n 0.0v 24.755n 0.0v 29.745n 0.0v 29.755n 1.1v 34.745n 1.1v 34.755n 1.1v 39.745n 1.1v 39.755n 1.1v 44.745n 1.1v 44.755n 1.1v 49.745n 1.1v 49.755n 1.1v 54.745n 1.1v 54.755n 1.1v 59.745n 1.1v 59.755n 0.0v 64.745n 0.0v 64.755n 0.0v 69.745n 0.0v 69.755n 0.0v 74.745n 0.0v 74.755n 0.0v 79.745n 0.0v 79.755n 1.1v 84.745n 1.1v 84.755n 1.1v 89.745n 1.1v 89.755n 1.1v 94.745n 1.1v 94.755n 1.1v 99.745n 1.1v 99.755n 1.1v 104.745n 1.1v 104.755n 1.1v 109.745n 1.1v 109.755n 1.1v 114.745n 1.1v 114.755n 0.0v 119.745n 0.0v 119.755n 0.0v 124.745n 0.0v 124.755n 0.0v 129.745n 0.0v 129.755n 1.1v 134.745n 1.1v 134.755n 1.1v 139.745n 1.1v 139.755n 0.0v 144.745n 0.0v 144.755n 0.0v 149.745n 0.0v 149.755n 1.1v 154.745n 1.1v 154.755n 1.1v 159.745n 1.1v 159.755n 1.1v 164.745n 1.1v 164.755n 1.1v 169.745n 1.1v 169.755n 1.1v 174.745n 1.1v 174.755n 1.1v 179.745n 1.1v 179.755n 1.1v 184.745n 1.1v 184.755n 1.1v 189.745n 1.1v 189.755n 1.1v 194.745n 1.1v 194.755n 1.1v 199.745n 1.1v 199.755n 1.1v 204.745n 1.1v 204.755n 1.1v 209.745n 1.1v 209.755n 1.1v 214.745n 1.1v 214.755n 1.1v 219.745n 1.1v 219.755n 1.1v 224.745n 1.1v 224.755n 0.0v 229.745n 0.0v 229.755n 0.0v 234.745n 0.0v 234.755n 0.0v 239.745n 0.0v 239.755n 0.0v 244.745n 0.0v 244.755n 0.0v 249.745n 0.0v 249.755n 0.0v 254.745n 0.0v 254.755n 0.0v 259.745n 0.0v 259.755n 0.0v 264.745n 0.0v 264.755n 0.0v 269.745n 0.0v 269.755n 1.1v 274.745n 1.1v 274.755n 1.1v 279.745n 1.1v 279.755n 1.1v 284.745n 1.1v 284.755n 1.1v 289.745n 1.1v 289.755n 1.1v 294.745n 1.1v 294.755n 1.1v 299.745n 1.1v 299.755n 1.1v 304.745n 1.1v 304.755n 1.1v 309.745n 1.1v 309.755n 1.1v 314.745n 1.1v 314.755n 1.1v 319.745n 1.1v 319.755n 1.1v 324.745n 1.1v 324.755n 1.1v 329.745n 1.1v 329.755n 1.1v 334.745n 1.1v 334.755n 1.1v 339.745n 1.1v 339.755n 1.1v 344.745n 1.1v 344.755n 1.1v 349.745n 1.1v 349.755n 1.1v 354.745n 1.1v 354.755n 1.1v 359.745n 1.1v 359.755n 1.1v 364.745n 1.1v 364.755n 1.1v 369.745n 1.1v 369.755n 1.1v 374.745n 1.1v 374.755n 1.1v 379.745n 1.1v 379.755n 0.0v 384.745n 0.0v 384.755n 0.0v 389.745n 0.0v 389.755n 0.0v 394.745n 0.0v 394.755n 0.0v 399.745n 0.0v 399.755n 0.0v 404.745n 0.0v 404.755n 0.0v 409.745n 0.0v 409.755n 0.0v 414.745n 0.0v 414.755n 0.0v 419.745n 0.0v 419.755n 0.0v 424.745n 0.0v 424.755n 0.0v 429.745n 0.0v 429.755n 0.0v 434.745n 0.0v 434.755n 0.0v 439.745n 0.0v 439.755n 0.0v 444.745n 0.0v 444.755n 0.0v 449.745n 0.0v 449.755n 0.0v 454.745n 0.0v 454.755n 0.0v 459.745n 0.0v 459.755n 0.0v 464.745n 0.0v 464.755n 0.0v 469.745n 0.0v 469.755n 1.1v 474.745n 1.1v 474.755n 0.0v 479.745n 0.0v 479.755n 0.0v 484.745n 0.0v 484.755n 0.0v 489.745n 0.0v 489.755n 0.0v 494.745n 0.0v 494.755n 0.0v 499.745n 0.0v 499.755n 0.0v 504.745n 0.0v 504.755n 0.0v 509.745n 0.0v 509.755n 0.0v 514.745n 0.0v 514.755n 0.0v 519.745n 0.0v 519.755n 1.1v 524.745n 1.1v 524.755n 0.0v 529.745n 0.0v 529.755n 0.0v 534.745n 0.0v 534.755n 1.1v 539.745n 1.1v 539.755n 1.1v 544.745n 1.1v 544.755n 1.1v 549.745n 1.1v 549.755n 1.1v 554.745n 1.1v 554.755n 1.1v 559.745n 1.1v 559.755n 1.1v 564.745n 1.1v 564.755n 1.1v 569.745n 1.1v 569.755n 1.1v 574.745n 1.1v 574.755n 1.1v 579.745n 1.1v 579.755n 1.1v 584.745n 1.1v 584.755n 1.1v 589.745n 1.1v 589.755n 1.1v 594.745n 1.1v 594.755n 1.1v 599.745n 1.1v 599.755n 1.1v 604.745n 1.1v 604.755n 1.1v 609.745n 1.1v 609.755n 1.1v 614.745n 1.1v 614.755n 1.1v 619.745n 1.1v 619.755n 0.0v 624.745n 0.0v 624.755n 0.0v 629.745n 0.0v 629.755n 0.0v 634.745n 0.0v 634.755n 0.0v 639.745n 0.0v 639.755n 0.0v 644.745n 0.0v 644.755n 0.0v 649.745n 0.0v 649.755n 0.0v 654.745n 0.0v 654.755n 0.0v 659.745n 0.0v 659.755n 1.1v 664.745n 1.1v 664.755n 0.0v 669.745n 0.0v 669.755n 0.0v 674.745n 0.0v 674.755n 0.0v 679.745n 0.0v 679.755n 0.0v 684.745n 0.0v 684.755n 0.0v 689.745n 0.0v 689.755n 0.0v 694.745n 0.0v 694.755n 0.0v 699.745n 0.0v 699.755n 0.0v 704.745n 0.0v 704.755n 0.0v 709.745n 0.0v 709.755n 1.1v 714.745n 1.1v 714.755n 0.0v 719.745n 0.0v 719.755n 0.0v 724.745n 0.0v 724.755n 0.0v 729.745n 0.0v 729.755n 0.0v 734.745n 0.0v 734.755n 0.0v 739.745n 0.0v 739.755n 0.0v 744.745n 0.0v 744.755n 0.0v 749.745n 0.0v 749.755n 0.0v 754.745n 0.0v 754.755n 0.0v 759.745n 0.0v 759.755n 1.1v 764.745n 1.1v 764.755n 1.1v 769.745n 1.1v 769.755n 0.0v 774.745n 0.0v 774.755n 0.0v 779.745n 0.0v 779.755n 0.0v 784.745n 0.0v 784.755n 1.1v 789.745n 1.1v 789.755n 1.1v 794.745n 1.1v 794.755n 0.0v 799.745n 0.0v 799.755n 0.0v 804.745n 0.0v 804.755n 0.0v 809.745n 0.0v 809.755n 0.0v 814.745n 0.0v 814.755n 0.0v 819.745n 0.0v 819.755n 0.0v 824.745n 0.0v 824.755n 0.0v 829.745n 0.0v 829.755n 0.0v 834.745n 0.0v 834.755n 0.0v 839.745n 0.0v 839.755n 0.0v 844.745n 0.0v 844.755n 1.1v 849.745n 1.1v 849.755n 1.1v 854.745n 1.1v 854.755n 1.1v 859.745n 1.1v 859.755n 1.1v 864.745n 1.1v 864.755n 0.0v 869.745n 0.0v 869.755n 0.0v 874.745n 0.0v 874.755n 1.1v 879.745n 1.1v 879.755n 1.1v 884.745n 1.1v 884.755n 1.1v 889.745n 1.1v 889.755n 1.1v 894.745n 1.1v 894.755n 1.1v 899.745n 1.1v 899.755n 0.0v 904.745n 0.0v 904.755n 0.0v 909.745n 0.0v 909.755n 1.1v 914.745n 1.1v 914.755n 1.1v 919.745n 1.1v 919.755n 1.1v 924.745n 1.1v 924.755n 1.1v 929.745n 1.1v 929.755n 1.1v 934.745n 1.1v 934.755n 1.1v 939.745n 1.1v 939.755n 1.1v 944.745n 1.1v 944.755n 1.1v 949.745n 1.1v 949.755n 1.1v 954.745n 1.1v 954.755n 1.1v 959.745n 1.1v 959.755n 1.1v 964.745n 1.1v 964.755n 1.1v 969.745n 1.1v 969.755n 1.1v 974.745n 1.1v 974.755n 0.0v 979.745n 0.0v 979.755n 0.0v 984.745n 0.0v 984.755n 0.0v 989.745n 0.0v 989.755n 0.0v 994.745n 0.0v 994.755n 0.0v 999.745n 0.0v 999.755n 0.0v 1004.745n 0.0v 1004.755n 0.0v 1009.745n 0.0v 1009.755n 0.0v 1014.745n 0.0v 1014.755n 0.0v 1019.745n 0.0v 1019.755n 0.0v 1024.745n 0.0v 1024.755n 0.0v )
* (time, data): [(0, 0), (5, 0), (10, 0), (15, 0), (20, 0), (25, 0), (30, 1), (35, 1), (40, 1), (45, 1), (50, 1), (55, 1), (60, 0), (65, 0), (70, 0), (75, 0), (80, 0), (85, 0), (90, 0), (95, 1), (100, 1), (105, 1), (110, 1), (115, 1), (120, 1), (125, 1), (130, 1), (135, 1), (140, 0), (145, 0), (150, 1), (155, 1), (160, 1), (165, 1), (170, 1), (175, 1), (180, 1), (185, 1), (190, 1), (195, 1), (200, 1), (205, 1), (210, 1), (215, 1), (220, 1), (225, 0), (230, 0), (235, 0), (240, 0), (245, 0), (250, 0), (255, 0), (260, 0), (265, 0), (270, 1), (275, 1), (280, 1), (285, 1), (290, 1), (295, 1), (300, 1), (305, 1), (310, 1), (315, 1), (320, 1), (325, 1), (330, 1), (335, 1), (340, 1), (345, 1), (350, 1), (355, 0), (360, 0), (365, 0), (370, 0), (375, 0), (380, 0), (385, 0), (390, 0), (395, 0), (400, 0), (405, 0), (410, 0), (415, 0), (420, 0), (425, 0), (430, 0), (435, 0), (440, 0), (445, 0), (450, 0), (455, 0), (460, 0), (465, 0), (470, 0), (475, 0), (480, 0), (485, 0), (490, 0), (495, 0), (500, 0), (505, 0), (510, 0), (515, 0), (520, 1), (525, 1), (530, 1), (535, 1), (540, 1), (545, 1), (550, 1), (555, 1), (560, 1), (565, 1), (570, 1), (575, 1), (580, 1), (585, 1), (590, 1), (595, 1), (600, 1), (605, 1), (610, 1), (615, 1), (620, 1), (625, 1), (630, 1), (635, 1), (640, 1), (645, 0), (650, 0), (655, 0), (660, 1), (665, 1), (670, 1), (675, 0), (680, 0), (685, 0), (690, 0), (695, 0), (700, 0), (705, 0), (710, 0), (715, 0), (720, 0), (725, 0), (730, 0), (735, 0), (740, 1), (745, 1), (750, 1), (755, 1), (760, 0), (765, 0), (770, 0), (775, 0), (780, 0), (785, 0), (790, 0), (795, 1), (800, 1), (805, 1), (810, 1), (815, 1), (820, 1), (825, 1), (830, 1), (835, 1), (840, 1), (845, 1), (850, 1), (855, 1), (860, 0), (865, 0), (870, 0), (875, 0), (880, 0), (885, 0), (890, 1), (895, 1), (900, 0), (905, 0), (910, 0), (915, 0), (920, 0), (925, 0), (930, 0), (935, 0), (940, 0), (945, 0), (950, 0), (955, 0), (960, 0), (965, 0), (970, 0), (975, 0), (980, 0), (985, 0), (990, 0), (995, 0), (1000, 0), (1005, 0), (1010, 0), (1015, 0), (1020, 0), (1025, 0)]
Vdin0_1  din0_1  0 PWL (0n 0.0v 4.745n 0.0v 4.755n 0.0v 9.745n 0.0v 9.755n 0.0v 14.745n 0.0v 14.755n 0.0v 19.745n 0.0v 19.755n 0.0v 24.745n 0.0v 24.755n 0.0v 29.745n 0.0v 29.755n 1.1v 34.745n 1.1v 34.755n 1.1v 39.745n 1.1v 39.755n 1.1v 44.745n 1.1v 44.755n 1.1v 49.745n 1.1v 49.755n 1.1v 54.745n 1.1v 54.755n 1.1v 59.745n 1.1v 59.755n 0.0v 64.745n 0.0v 64.755n 0.0v 69.745n 0.0v 69.755n 0.0v 74.745n 0.0v 74.755n 0.0v 79.745n 0.0v 79.755n 0.0v 84.745n 0.0v 84.755n 0.0v 89.745n 0.0v 89.755n 0.0v 94.745n 0.0v 94.755n 1.1v 99.745n 1.1v 99.755n 1.1v 104.745n 1.1v 104.755n 1.1v 109.745n 1.1v 109.755n 1.1v 114.745n 1.1v 114.755n 1.1v 119.745n 1.1v 119.755n 1.1v 124.745n 1.1v 124.755n 1.1v 129.745n 1.1v 129.755n 1.1v 134.745n 1.1v 134.755n 1.1v 139.745n 1.1v 139.755n 0.0v 144.745n 0.0v 144.755n 0.0v 149.745n 0.0v 149.755n 1.1v 154.745n 1.1v 154.755n 1.1v 159.745n 1.1v 159.755n 1.1v 164.745n 1.1v 164.755n 1.1v 169.745n 1.1v 169.755n 1.1v 174.745n 1.1v 174.755n 1.1v 179.745n 1.1v 179.755n 1.1v 184.745n 1.1v 184.755n 1.1v 189.745n 1.1v 189.755n 1.1v 194.745n 1.1v 194.755n 1.1v 199.745n 1.1v 199.755n 1.1v 204.745n 1.1v 204.755n 1.1v 209.745n 1.1v 209.755n 1.1v 214.745n 1.1v 214.755n 1.1v 219.745n 1.1v 219.755n 1.1v 224.745n 1.1v 224.755n 0.0v 229.745n 0.0v 229.755n 0.0v 234.745n 0.0v 234.755n 0.0v 239.745n 0.0v 239.755n 0.0v 244.745n 0.0v 244.755n 0.0v 249.745n 0.0v 249.755n 0.0v 254.745n 0.0v 254.755n 0.0v 259.745n 0.0v 259.755n 0.0v 264.745n 0.0v 264.755n 0.0v 269.745n 0.0v 269.755n 1.1v 274.745n 1.1v 274.755n 1.1v 279.745n 1.1v 279.755n 1.1v 284.745n 1.1v 284.755n 1.1v 289.745n 1.1v 289.755n 1.1v 294.745n 1.1v 294.755n 1.1v 299.745n 1.1v 299.755n 1.1v 304.745n 1.1v 304.755n 1.1v 309.745n 1.1v 309.755n 1.1v 314.745n 1.1v 314.755n 1.1v 319.745n 1.1v 319.755n 1.1v 324.745n 1.1v 324.755n 1.1v 329.745n 1.1v 329.755n 1.1v 334.745n 1.1v 334.755n 1.1v 339.745n 1.1v 339.755n 1.1v 344.745n 1.1v 344.755n 1.1v 349.745n 1.1v 349.755n 1.1v 354.745n 1.1v 354.755n 0.0v 359.745n 0.0v 359.755n 0.0v 364.745n 0.0v 364.755n 0.0v 369.745n 0.0v 369.755n 0.0v 374.745n 0.0v 374.755n 0.0v 379.745n 0.0v 379.755n 0.0v 384.745n 0.0v 384.755n 0.0v 389.745n 0.0v 389.755n 0.0v 394.745n 0.0v 394.755n 0.0v 399.745n 0.0v 399.755n 0.0v 404.745n 0.0v 404.755n 0.0v 409.745n 0.0v 409.755n 0.0v 414.745n 0.0v 414.755n 0.0v 419.745n 0.0v 419.755n 0.0v 424.745n 0.0v 424.755n 0.0v 429.745n 0.0v 429.755n 0.0v 434.745n 0.0v 434.755n 0.0v 439.745n 0.0v 439.755n 0.0v 444.745n 0.0v 444.755n 0.0v 449.745n 0.0v 449.755n 0.0v 454.745n 0.0v 454.755n 0.0v 459.745n 0.0v 459.755n 0.0v 464.745n 0.0v 464.755n 0.0v 469.745n 0.0v 469.755n 0.0v 474.745n 0.0v 474.755n 0.0v 479.745n 0.0v 479.755n 0.0v 484.745n 0.0v 484.755n 0.0v 489.745n 0.0v 489.755n 0.0v 494.745n 0.0v 494.755n 0.0v 499.745n 0.0v 499.755n 0.0v 504.745n 0.0v 504.755n 0.0v 509.745n 0.0v 509.755n 0.0v 514.745n 0.0v 514.755n 0.0v 519.745n 0.0v 519.755n 1.1v 524.745n 1.1v 524.755n 1.1v 529.745n 1.1v 529.755n 1.1v 534.745n 1.1v 534.755n 1.1v 539.745n 1.1v 539.755n 1.1v 544.745n 1.1v 544.755n 1.1v 549.745n 1.1v 549.755n 1.1v 554.745n 1.1v 554.755n 1.1v 559.745n 1.1v 559.755n 1.1v 564.745n 1.1v 564.755n 1.1v 569.745n 1.1v 569.755n 1.1v 574.745n 1.1v 574.755n 1.1v 579.745n 1.1v 579.755n 1.1v 584.745n 1.1v 584.755n 1.1v 589.745n 1.1v 589.755n 1.1v 594.745n 1.1v 594.755n 1.1v 599.745n 1.1v 599.755n 1.1v 604.745n 1.1v 604.755n 1.1v 609.745n 1.1v 609.755n 1.1v 614.745n 1.1v 614.755n 1.1v 619.745n 1.1v 619.755n 1.1v 624.745n 1.1v 624.755n 1.1v 629.745n 1.1v 629.755n 1.1v 634.745n 1.1v 634.755n 1.1v 639.745n 1.1v 639.755n 1.1v 644.745n 1.1v 644.755n 0.0v 649.745n 0.0v 649.755n 0.0v 654.745n 0.0v 654.755n 0.0v 659.745n 0.0v 659.755n 1.1v 664.745n 1.1v 664.755n 1.1v 669.745n 1.1v 669.755n 1.1v 674.745n 1.1v 674.755n 0.0v 679.745n 0.0v 679.755n 0.0v 684.745n 0.0v 684.755n 0.0v 689.745n 0.0v 689.755n 0.0v 694.745n 0.0v 694.755n 0.0v 699.745n 0.0v 699.755n 0.0v 704.745n 0.0v 704.755n 0.0v 709.745n 0.0v 709.755n 0.0v 714.745n 0.0v 714.755n 0.0v 719.745n 0.0v 719.755n 0.0v 724.745n 0.0v 724.755n 0.0v 729.745n 0.0v 729.755n 0.0v 734.745n 0.0v 734.755n 0.0v 739.745n 0.0v 739.755n 1.1v 744.745n 1.1v 744.755n 1.1v 749.745n 1.1v 749.755n 1.1v 754.745n 1.1v 754.755n 1.1v 759.745n 1.1v 759.755n 0.0v 764.745n 0.0v 764.755n 0.0v 769.745n 0.0v 769.755n 0.0v 774.745n 0.0v 774.755n 0.0v 779.745n 0.0v 779.755n 0.0v 784.745n 0.0v 784.755n 0.0v 789.745n 0.0v 789.755n 0.0v 794.745n 0.0v 794.755n 1.1v 799.745n 1.1v 799.755n 1.1v 804.745n 1.1v 804.755n 1.1v 809.745n 1.1v 809.755n 1.1v 814.745n 1.1v 814.755n 1.1v 819.745n 1.1v 819.755n 1.1v 824.745n 1.1v 824.755n 1.1v 829.745n 1.1v 829.755n 1.1v 834.745n 1.1v 834.755n 1.1v 839.745n 1.1v 839.755n 1.1v 844.745n 1.1v 844.755n 1.1v 849.745n 1.1v 849.755n 1.1v 854.745n 1.1v 854.755n 1.1v 859.745n 1.1v 859.755n 0.0v 864.745n 0.0v 864.755n 0.0v 869.745n 0.0v 869.755n 0.0v 874.745n 0.0v 874.755n 0.0v 879.745n 0.0v 879.755n 0.0v 884.745n 0.0v 884.755n 0.0v 889.745n 0.0v 889.755n 1.1v 894.745n 1.1v 894.755n 1.1v 899.745n 1.1v 899.755n 0.0v 904.745n 0.0v 904.755n 0.0v 909.745n 0.0v 909.755n 0.0v 914.745n 0.0v 914.755n 0.0v 919.745n 0.0v 919.755n 0.0v 924.745n 0.0v 924.755n 0.0v 929.745n 0.0v 929.755n 0.0v 934.745n 0.0v 934.755n 0.0v 939.745n 0.0v 939.755n 0.0v 944.745n 0.0v 944.755n 0.0v 949.745n 0.0v 949.755n 0.0v 954.745n 0.0v 954.755n 0.0v 959.745n 0.0v 959.755n 0.0v 964.745n 0.0v 964.755n 0.0v 969.745n 0.0v 969.755n 0.0v 974.745n 0.0v 974.755n 0.0v 979.745n 0.0v 979.755n 0.0v 984.745n 0.0v 984.755n 0.0v 989.745n 0.0v 989.755n 0.0v 994.745n 0.0v 994.755n 0.0v 999.745n 0.0v 999.755n 0.0v 1004.745n 0.0v 1004.755n 0.0v 1009.745n 0.0v 1009.755n 0.0v 1014.745n 0.0v 1014.755n 0.0v 1019.745n 0.0v 1019.755n 0.0v 1024.745n 0.0v 1024.755n 0.0v )
* (time, data): [(0, 0), (5, 0), (10, 0), (15, 1), (20, 1), (25, 1), (30, 0), (35, 1), (40, 1), (45, 1), (50, 1), (55, 1), (60, 0), (65, 0), (70, 0), (75, 0), (80, 1), (85, 1), (90, 1), (95, 0), (100, 0), (105, 0), (110, 0), (115, 1), (120, 1), (125, 1), (130, 1), (135, 0), (140, 1), (145, 1), (150, 1), (155, 1), (160, 1), (165, 1), (170, 1), (175, 1), (180, 1), (185, 1), (190, 1), (195, 1), (200, 1), (205, 1), (210, 1), (215, 1), (220, 1), (225, 1), (230, 1), (235, 1), (240, 1), (245, 1), (250, 1), (255, 1), (260, 1), (265, 1), (270, 1), (275, 1), (280, 1), (285, 1), (290, 1), (295, 1), (300, 1), (305, 1), (310, 1), (315, 1), (320, 1), (325, 1), (330, 1), (335, 1), (340, 1), (345, 1), (350, 1), (355, 0), (360, 0), (365, 0), (370, 0), (375, 0), (380, 0), (385, 0), (390, 0), (395, 0), (400, 0), (405, 0), (410, 0), (415, 0), (420, 1), (425, 1), (430, 1), (435, 1), (440, 1), (445, 1), (450, 1), (455, 1), (460, 1), (465, 1), (470, 0), (475, 1), (480, 1), (485, 1), (490, 1), (495, 0), (500, 0), (505, 0), (510, 0), (515, 0), (520, 1), (525, 1), (530, 1), (535, 0), (540, 0), (545, 0), (550, 0), (555, 0), (560, 0), (565, 0), (570, 0), (575, 0), (580, 0), (585, 0), (590, 0), (595, 0), (600, 0), (605, 0), (610, 0), (615, 0), (620, 0), (625, 0), (630, 0), (635, 0), (640, 0), (645, 1), (650, 1), (655, 1), (660, 1), (665, 0), (670, 0), (675, 1), (680, 0), (685, 0), (690, 0), (695, 0), (700, 0), (705, 0), (710, 0), (715, 1), (720, 1), (725, 1), (730, 1), (735, 1), (740, 1), (745, 1), (750, 1), (755, 1), (760, 1), (765, 1), (770, 1), (775, 1), (780, 1), (785, 0), (790, 1), (795, 1), (800, 1), (805, 1), (810, 1), (815, 1), (820, 1), (825, 1), (830, 1), (835, 1), (840, 1), (845, 1), (850, 1), (855, 1), (860, 1), (865, 0), (870, 0), (875, 1), (880, 1), (885, 1), (890, 1), (895, 1), (900, 0), (905, 0), (910, 0), (915, 0), (920, 0), (925, 0), (930, 0), (935, 0), (940, 0), (945, 0), (950, 0), (955, 0), (960, 0), (965, 0), (970, 0), (975, 1), (980, 1), (985, 1), (990, 1), (995, 1), (1000, 1), (1005, 1), (1010, 1), (1015, 1), (1020, 1), (1025, 1)]
Vdin0_2  din0_2  0 PWL (0n 0.0v 4.745n 0.0v 4.755n 0.0v 9.745n 0.0v 9.755n 0.0v 14.745n 0.0v 14.755n 1.1v 19.745n 1.1v 19.755n 1.1v 24.745n 1.1v 24.755n 1.1v 29.745n 1.1v 29.755n 0.0v 34.745n 0.0v 34.755n 1.1v 39.745n 1.1v 39.755n 1.1v 44.745n 1.1v 44.755n 1.1v 49.745n 1.1v 49.755n 1.1v 54.745n 1.1v 54.755n 1.1v 59.745n 1.1v 59.755n 0.0v 64.745n 0.0v 64.755n 0.0v 69.745n 0.0v 69.755n 0.0v 74.745n 0.0v 74.755n 0.0v 79.745n 0.0v 79.755n 1.1v 84.745n 1.1v 84.755n 1.1v 89.745n 1.1v 89.755n 1.1v 94.745n 1.1v 94.755n 0.0v 99.745n 0.0v 99.755n 0.0v 104.745n 0.0v 104.755n 0.0v 109.745n 0.0v 109.755n 0.0v 114.745n 0.0v 114.755n 1.1v 119.745n 1.1v 119.755n 1.1v 124.745n 1.1v 124.755n 1.1v 129.745n 1.1v 129.755n 1.1v 134.745n 1.1v 134.755n 0.0v 139.745n 0.0v 139.755n 1.1v 144.745n 1.1v 144.755n 1.1v 149.745n 1.1v 149.755n 1.1v 154.745n 1.1v 154.755n 1.1v 159.745n 1.1v 159.755n 1.1v 164.745n 1.1v 164.755n 1.1v 169.745n 1.1v 169.755n 1.1v 174.745n 1.1v 174.755n 1.1v 179.745n 1.1v 179.755n 1.1v 184.745n 1.1v 184.755n 1.1v 189.745n 1.1v 189.755n 1.1v 194.745n 1.1v 194.755n 1.1v 199.745n 1.1v 199.755n 1.1v 204.745n 1.1v 204.755n 1.1v 209.745n 1.1v 209.755n 1.1v 214.745n 1.1v 214.755n 1.1v 219.745n 1.1v 219.755n 1.1v 224.745n 1.1v 224.755n 1.1v 229.745n 1.1v 229.755n 1.1v 234.745n 1.1v 234.755n 1.1v 239.745n 1.1v 239.755n 1.1v 244.745n 1.1v 244.755n 1.1v 249.745n 1.1v 249.755n 1.1v 254.745n 1.1v 254.755n 1.1v 259.745n 1.1v 259.755n 1.1v 264.745n 1.1v 264.755n 1.1v 269.745n 1.1v 269.755n 1.1v 274.745n 1.1v 274.755n 1.1v 279.745n 1.1v 279.755n 1.1v 284.745n 1.1v 284.755n 1.1v 289.745n 1.1v 289.755n 1.1v 294.745n 1.1v 294.755n 1.1v 299.745n 1.1v 299.755n 1.1v 304.745n 1.1v 304.755n 1.1v 309.745n 1.1v 309.755n 1.1v 314.745n 1.1v 314.755n 1.1v 319.745n 1.1v 319.755n 1.1v 324.745n 1.1v 324.755n 1.1v 329.745n 1.1v 329.755n 1.1v 334.745n 1.1v 334.755n 1.1v 339.745n 1.1v 339.755n 1.1v 344.745n 1.1v 344.755n 1.1v 349.745n 1.1v 349.755n 1.1v 354.745n 1.1v 354.755n 0.0v 359.745n 0.0v 359.755n 0.0v 364.745n 0.0v 364.755n 0.0v 369.745n 0.0v 369.755n 0.0v 374.745n 0.0v 374.755n 0.0v 379.745n 0.0v 379.755n 0.0v 384.745n 0.0v 384.755n 0.0v 389.745n 0.0v 389.755n 0.0v 394.745n 0.0v 394.755n 0.0v 399.745n 0.0v 399.755n 0.0v 404.745n 0.0v 404.755n 0.0v 409.745n 0.0v 409.755n 0.0v 414.745n 0.0v 414.755n 0.0v 419.745n 0.0v 419.755n 1.1v 424.745n 1.1v 424.755n 1.1v 429.745n 1.1v 429.755n 1.1v 434.745n 1.1v 434.755n 1.1v 439.745n 1.1v 439.755n 1.1v 444.745n 1.1v 444.755n 1.1v 449.745n 1.1v 449.755n 1.1v 454.745n 1.1v 454.755n 1.1v 459.745n 1.1v 459.755n 1.1v 464.745n 1.1v 464.755n 1.1v 469.745n 1.1v 469.755n 0.0v 474.745n 0.0v 474.755n 1.1v 479.745n 1.1v 479.755n 1.1v 484.745n 1.1v 484.755n 1.1v 489.745n 1.1v 489.755n 1.1v 494.745n 1.1v 494.755n 0.0v 499.745n 0.0v 499.755n 0.0v 504.745n 0.0v 504.755n 0.0v 509.745n 0.0v 509.755n 0.0v 514.745n 0.0v 514.755n 0.0v 519.745n 0.0v 519.755n 1.1v 524.745n 1.1v 524.755n 1.1v 529.745n 1.1v 529.755n 1.1v 534.745n 1.1v 534.755n 0.0v 539.745n 0.0v 539.755n 0.0v 544.745n 0.0v 544.755n 0.0v 549.745n 0.0v 549.755n 0.0v 554.745n 0.0v 554.755n 0.0v 559.745n 0.0v 559.755n 0.0v 564.745n 0.0v 564.755n 0.0v 569.745n 0.0v 569.755n 0.0v 574.745n 0.0v 574.755n 0.0v 579.745n 0.0v 579.755n 0.0v 584.745n 0.0v 584.755n 0.0v 589.745n 0.0v 589.755n 0.0v 594.745n 0.0v 594.755n 0.0v 599.745n 0.0v 599.755n 0.0v 604.745n 0.0v 604.755n 0.0v 609.745n 0.0v 609.755n 0.0v 614.745n 0.0v 614.755n 0.0v 619.745n 0.0v 619.755n 0.0v 624.745n 0.0v 624.755n 0.0v 629.745n 0.0v 629.755n 0.0v 634.745n 0.0v 634.755n 0.0v 639.745n 0.0v 639.755n 0.0v 644.745n 0.0v 644.755n 1.1v 649.745n 1.1v 649.755n 1.1v 654.745n 1.1v 654.755n 1.1v 659.745n 1.1v 659.755n 1.1v 664.745n 1.1v 664.755n 0.0v 669.745n 0.0v 669.755n 0.0v 674.745n 0.0v 674.755n 1.1v 679.745n 1.1v 679.755n 0.0v 684.745n 0.0v 684.755n 0.0v 689.745n 0.0v 689.755n 0.0v 694.745n 0.0v 694.755n 0.0v 699.745n 0.0v 699.755n 0.0v 704.745n 0.0v 704.755n 0.0v 709.745n 0.0v 709.755n 0.0v 714.745n 0.0v 714.755n 1.1v 719.745n 1.1v 719.755n 1.1v 724.745n 1.1v 724.755n 1.1v 729.745n 1.1v 729.755n 1.1v 734.745n 1.1v 734.755n 1.1v 739.745n 1.1v 739.755n 1.1v 744.745n 1.1v 744.755n 1.1v 749.745n 1.1v 749.755n 1.1v 754.745n 1.1v 754.755n 1.1v 759.745n 1.1v 759.755n 1.1v 764.745n 1.1v 764.755n 1.1v 769.745n 1.1v 769.755n 1.1v 774.745n 1.1v 774.755n 1.1v 779.745n 1.1v 779.755n 1.1v 784.745n 1.1v 784.755n 0.0v 789.745n 0.0v 789.755n 1.1v 794.745n 1.1v 794.755n 1.1v 799.745n 1.1v 799.755n 1.1v 804.745n 1.1v 804.755n 1.1v 809.745n 1.1v 809.755n 1.1v 814.745n 1.1v 814.755n 1.1v 819.745n 1.1v 819.755n 1.1v 824.745n 1.1v 824.755n 1.1v 829.745n 1.1v 829.755n 1.1v 834.745n 1.1v 834.755n 1.1v 839.745n 1.1v 839.755n 1.1v 844.745n 1.1v 844.755n 1.1v 849.745n 1.1v 849.755n 1.1v 854.745n 1.1v 854.755n 1.1v 859.745n 1.1v 859.755n 1.1v 864.745n 1.1v 864.755n 0.0v 869.745n 0.0v 869.755n 0.0v 874.745n 0.0v 874.755n 1.1v 879.745n 1.1v 879.755n 1.1v 884.745n 1.1v 884.755n 1.1v 889.745n 1.1v 889.755n 1.1v 894.745n 1.1v 894.755n 1.1v 899.745n 1.1v 899.755n 0.0v 904.745n 0.0v 904.755n 0.0v 909.745n 0.0v 909.755n 0.0v 914.745n 0.0v 914.755n 0.0v 919.745n 0.0v 919.755n 0.0v 924.745n 0.0v 924.755n 0.0v 929.745n 0.0v 929.755n 0.0v 934.745n 0.0v 934.755n 0.0v 939.745n 0.0v 939.755n 0.0v 944.745n 0.0v 944.755n 0.0v 949.745n 0.0v 949.755n 0.0v 954.745n 0.0v 954.755n 0.0v 959.745n 0.0v 959.755n 0.0v 964.745n 0.0v 964.755n 0.0v 969.745n 0.0v 969.755n 0.0v 974.745n 0.0v 974.755n 1.1v 979.745n 1.1v 979.755n 1.1v 984.745n 1.1v 984.755n 1.1v 989.745n 1.1v 989.755n 1.1v 994.745n 1.1v 994.755n 1.1v 999.745n 1.1v 999.755n 1.1v 1004.745n 1.1v 1004.755n 1.1v 1009.745n 1.1v 1009.755n 1.1v 1014.745n 1.1v 1014.755n 1.1v 1019.745n 1.1v 1019.755n 1.1v 1024.745n 1.1v 1024.755n 1.1v )
* (time, data): [(0, 0), (5, 1), (10, 0), (15, 0), (20, 0), (25, 0), (30, 1), (35, 0), (40, 0), (45, 0), (50, 0), (55, 0), (60, 1), (65, 1), (70, 1), (75, 1), (80, 1), (85, 1), (90, 1), (95, 1), (100, 1), (105, 1), (110, 1), (115, 1), (120, 1), (125, 1), (130, 0), (135, 0), (140, 1), (145, 1), (150, 1), (155, 1), (160, 1), (165, 1), (170, 1), (175, 1), (180, 1), (185, 1), (190, 1), (195, 1), (200, 1), (205, 1), (210, 1), (215, 1), (220, 1), (225, 1), (230, 1), (235, 1), (240, 1), (245, 1), (250, 1), (255, 1), (260, 1), (265, 1), (270, 1), (275, 1), (280, 1), (285, 1), (290, 1), (295, 1), (300, 1), (305, 1), (310, 1), (315, 1), (320, 1), (325, 1), (330, 1), (335, 1), (340, 1), (345, 1), (350, 1), (355, 0), (360, 0), (365, 0), (370, 0), (375, 0), (380, 0), (385, 0), (390, 0), (395, 0), (400, 0), (405, 0), (410, 0), (415, 0), (420, 0), (425, 0), (430, 0), (435, 0), (440, 0), (445, 0), (450, 0), (455, 0), (460, 0), (465, 0), (470, 0), (475, 1), (480, 1), (485, 1), (490, 1), (495, 0), (500, 0), (505, 0), (510, 0), (515, 0), (520, 1), (525, 1), (530, 1), (535, 1), (540, 1), (545, 1), (550, 1), (555, 1), (560, 1), (565, 1), (570, 1), (575, 1), (580, 1), (585, 1), (590, 1), (595, 1), (600, 1), (605, 1), (610, 1), (615, 1), (620, 0), (625, 0), (630, 0), (635, 0), (640, 0), (645, 0), (650, 0), (655, 0), (660, 1), (665, 1), (670, 1), (675, 0), (680, 1), (685, 1), (690, 1), (695, 1), (700, 1), (705, 1), (710, 0), (715, 0), (720, 0), (725, 0), (730, 0), (735, 0), (740, 1), (745, 1), (750, 1), (755, 1), (760, 0), (765, 0), (770, 1), (775, 1), (780, 1), (785, 1), (790, 1), (795, 0), (800, 0), (805, 0), (810, 0), (815, 0), (820, 0), (825, 0), (830, 0), (835, 0), (840, 0), (845, 1), (850, 1), (855, 1), (860, 1), (865, 0), (870, 0), (875, 0), (880, 0), (885, 0), (890, 0), (895, 0), (900, 1), (905, 1), (910, 0), (915, 0), (920, 0), (925, 0), (930, 0), (935, 0), (940, 0), (945, 0), (950, 0), (955, 0), (960, 0), (965, 0), (970, 0), (975, 0), (980, 0), (985, 0), (990, 0), (995, 0), (1000, 0), (1005, 0), (1010, 0), (1015, 0), (1020, 0), (1025, 0)]
Vdin0_3  din0_3  0 PWL (0n 0.0v 4.745n 0.0v 4.755n 1.1v 9.745n 1.1v 9.755n 0.0v 14.745n 0.0v 14.755n 0.0v 19.745n 0.0v 19.755n 0.0v 24.745n 0.0v 24.755n 0.0v 29.745n 0.0v 29.755n 1.1v 34.745n 1.1v 34.755n 0.0v 39.745n 0.0v 39.755n 0.0v 44.745n 0.0v 44.755n 0.0v 49.745n 0.0v 49.755n 0.0v 54.745n 0.0v 54.755n 0.0v 59.745n 0.0v 59.755n 1.1v 64.745n 1.1v 64.755n 1.1v 69.745n 1.1v 69.755n 1.1v 74.745n 1.1v 74.755n 1.1v 79.745n 1.1v 79.755n 1.1v 84.745n 1.1v 84.755n 1.1v 89.745n 1.1v 89.755n 1.1v 94.745n 1.1v 94.755n 1.1v 99.745n 1.1v 99.755n 1.1v 104.745n 1.1v 104.755n 1.1v 109.745n 1.1v 109.755n 1.1v 114.745n 1.1v 114.755n 1.1v 119.745n 1.1v 119.755n 1.1v 124.745n 1.1v 124.755n 1.1v 129.745n 1.1v 129.755n 0.0v 134.745n 0.0v 134.755n 0.0v 139.745n 0.0v 139.755n 1.1v 144.745n 1.1v 144.755n 1.1v 149.745n 1.1v 149.755n 1.1v 154.745n 1.1v 154.755n 1.1v 159.745n 1.1v 159.755n 1.1v 164.745n 1.1v 164.755n 1.1v 169.745n 1.1v 169.755n 1.1v 174.745n 1.1v 174.755n 1.1v 179.745n 1.1v 179.755n 1.1v 184.745n 1.1v 184.755n 1.1v 189.745n 1.1v 189.755n 1.1v 194.745n 1.1v 194.755n 1.1v 199.745n 1.1v 199.755n 1.1v 204.745n 1.1v 204.755n 1.1v 209.745n 1.1v 209.755n 1.1v 214.745n 1.1v 214.755n 1.1v 219.745n 1.1v 219.755n 1.1v 224.745n 1.1v 224.755n 1.1v 229.745n 1.1v 229.755n 1.1v 234.745n 1.1v 234.755n 1.1v 239.745n 1.1v 239.755n 1.1v 244.745n 1.1v 244.755n 1.1v 249.745n 1.1v 249.755n 1.1v 254.745n 1.1v 254.755n 1.1v 259.745n 1.1v 259.755n 1.1v 264.745n 1.1v 264.755n 1.1v 269.745n 1.1v 269.755n 1.1v 274.745n 1.1v 274.755n 1.1v 279.745n 1.1v 279.755n 1.1v 284.745n 1.1v 284.755n 1.1v 289.745n 1.1v 289.755n 1.1v 294.745n 1.1v 294.755n 1.1v 299.745n 1.1v 299.755n 1.1v 304.745n 1.1v 304.755n 1.1v 309.745n 1.1v 309.755n 1.1v 314.745n 1.1v 314.755n 1.1v 319.745n 1.1v 319.755n 1.1v 324.745n 1.1v 324.755n 1.1v 329.745n 1.1v 329.755n 1.1v 334.745n 1.1v 334.755n 1.1v 339.745n 1.1v 339.755n 1.1v 344.745n 1.1v 344.755n 1.1v 349.745n 1.1v 349.755n 1.1v 354.745n 1.1v 354.755n 0.0v 359.745n 0.0v 359.755n 0.0v 364.745n 0.0v 364.755n 0.0v 369.745n 0.0v 369.755n 0.0v 374.745n 0.0v 374.755n 0.0v 379.745n 0.0v 379.755n 0.0v 384.745n 0.0v 384.755n 0.0v 389.745n 0.0v 389.755n 0.0v 394.745n 0.0v 394.755n 0.0v 399.745n 0.0v 399.755n 0.0v 404.745n 0.0v 404.755n 0.0v 409.745n 0.0v 409.755n 0.0v 414.745n 0.0v 414.755n 0.0v 419.745n 0.0v 419.755n 0.0v 424.745n 0.0v 424.755n 0.0v 429.745n 0.0v 429.755n 0.0v 434.745n 0.0v 434.755n 0.0v 439.745n 0.0v 439.755n 0.0v 444.745n 0.0v 444.755n 0.0v 449.745n 0.0v 449.755n 0.0v 454.745n 0.0v 454.755n 0.0v 459.745n 0.0v 459.755n 0.0v 464.745n 0.0v 464.755n 0.0v 469.745n 0.0v 469.755n 0.0v 474.745n 0.0v 474.755n 1.1v 479.745n 1.1v 479.755n 1.1v 484.745n 1.1v 484.755n 1.1v 489.745n 1.1v 489.755n 1.1v 494.745n 1.1v 494.755n 0.0v 499.745n 0.0v 499.755n 0.0v 504.745n 0.0v 504.755n 0.0v 509.745n 0.0v 509.755n 0.0v 514.745n 0.0v 514.755n 0.0v 519.745n 0.0v 519.755n 1.1v 524.745n 1.1v 524.755n 1.1v 529.745n 1.1v 529.755n 1.1v 534.745n 1.1v 534.755n 1.1v 539.745n 1.1v 539.755n 1.1v 544.745n 1.1v 544.755n 1.1v 549.745n 1.1v 549.755n 1.1v 554.745n 1.1v 554.755n 1.1v 559.745n 1.1v 559.755n 1.1v 564.745n 1.1v 564.755n 1.1v 569.745n 1.1v 569.755n 1.1v 574.745n 1.1v 574.755n 1.1v 579.745n 1.1v 579.755n 1.1v 584.745n 1.1v 584.755n 1.1v 589.745n 1.1v 589.755n 1.1v 594.745n 1.1v 594.755n 1.1v 599.745n 1.1v 599.755n 1.1v 604.745n 1.1v 604.755n 1.1v 609.745n 1.1v 609.755n 1.1v 614.745n 1.1v 614.755n 1.1v 619.745n 1.1v 619.755n 0.0v 624.745n 0.0v 624.755n 0.0v 629.745n 0.0v 629.755n 0.0v 634.745n 0.0v 634.755n 0.0v 639.745n 0.0v 639.755n 0.0v 644.745n 0.0v 644.755n 0.0v 649.745n 0.0v 649.755n 0.0v 654.745n 0.0v 654.755n 0.0v 659.745n 0.0v 659.755n 1.1v 664.745n 1.1v 664.755n 1.1v 669.745n 1.1v 669.755n 1.1v 674.745n 1.1v 674.755n 0.0v 679.745n 0.0v 679.755n 1.1v 684.745n 1.1v 684.755n 1.1v 689.745n 1.1v 689.755n 1.1v 694.745n 1.1v 694.755n 1.1v 699.745n 1.1v 699.755n 1.1v 704.745n 1.1v 704.755n 1.1v 709.745n 1.1v 709.755n 0.0v 714.745n 0.0v 714.755n 0.0v 719.745n 0.0v 719.755n 0.0v 724.745n 0.0v 724.755n 0.0v 729.745n 0.0v 729.755n 0.0v 734.745n 0.0v 734.755n 0.0v 739.745n 0.0v 739.755n 1.1v 744.745n 1.1v 744.755n 1.1v 749.745n 1.1v 749.755n 1.1v 754.745n 1.1v 754.755n 1.1v 759.745n 1.1v 759.755n 0.0v 764.745n 0.0v 764.755n 0.0v 769.745n 0.0v 769.755n 1.1v 774.745n 1.1v 774.755n 1.1v 779.745n 1.1v 779.755n 1.1v 784.745n 1.1v 784.755n 1.1v 789.745n 1.1v 789.755n 1.1v 794.745n 1.1v 794.755n 0.0v 799.745n 0.0v 799.755n 0.0v 804.745n 0.0v 804.755n 0.0v 809.745n 0.0v 809.755n 0.0v 814.745n 0.0v 814.755n 0.0v 819.745n 0.0v 819.755n 0.0v 824.745n 0.0v 824.755n 0.0v 829.745n 0.0v 829.755n 0.0v 834.745n 0.0v 834.755n 0.0v 839.745n 0.0v 839.755n 0.0v 844.745n 0.0v 844.755n 1.1v 849.745n 1.1v 849.755n 1.1v 854.745n 1.1v 854.755n 1.1v 859.745n 1.1v 859.755n 1.1v 864.745n 1.1v 864.755n 0.0v 869.745n 0.0v 869.755n 0.0v 874.745n 0.0v 874.755n 0.0v 879.745n 0.0v 879.755n 0.0v 884.745n 0.0v 884.755n 0.0v 889.745n 0.0v 889.755n 0.0v 894.745n 0.0v 894.755n 0.0v 899.745n 0.0v 899.755n 1.1v 904.745n 1.1v 904.755n 1.1v 909.745n 1.1v 909.755n 0.0v 914.745n 0.0v 914.755n 0.0v 919.745n 0.0v 919.755n 0.0v 924.745n 0.0v 924.755n 0.0v 929.745n 0.0v 929.755n 0.0v 934.745n 0.0v 934.755n 0.0v 939.745n 0.0v 939.755n 0.0v 944.745n 0.0v 944.755n 0.0v 949.745n 0.0v 949.755n 0.0v 954.745n 0.0v 954.755n 0.0v 959.745n 0.0v 959.755n 0.0v 964.745n 0.0v 964.755n 0.0v 969.745n 0.0v 969.755n 0.0v 974.745n 0.0v 974.755n 0.0v 979.745n 0.0v 979.755n 0.0v 984.745n 0.0v 984.755n 0.0v 989.745n 0.0v 989.755n 0.0v 994.745n 0.0v 994.755n 0.0v 999.745n 0.0v 999.755n 0.0v 1004.745n 0.0v 1004.755n 0.0v 1009.745n 0.0v 1009.755n 0.0v 1014.745n 0.0v 1014.755n 0.0v 1019.745n 0.0v 1019.755n 0.0v 1024.745n 0.0v 1024.755n 0.0v )
* (time, data): [(0, 0), (5, 0), (10, 0), (15, 0), (20, 0), (25, 0), (30, 0), (35, 1), (40, 1), (45, 1), (50, 1), (55, 1), (60, 1), (65, 1), (70, 1), (75, 1), (80, 1), (85, 1), (90, 1), (95, 0), (100, 0), (105, 0), (110, 1), (115, 1), (120, 1), (125, 1), (130, 0), (135, 0), (140, 0), (145, 0), (150, 0), (155, 0), (160, 0), (165, 0), (170, 0), (175, 0), (180, 0), (185, 0), (190, 0), (195, 0), (200, 0), (205, 0), (210, 0), (215, 0), (220, 0), (225, 1), (230, 1), (235, 1), (240, 1), (245, 1), (250, 1), (255, 1), (260, 1), (265, 0), (270, 0), (275, 0), (280, 0), (285, 0), (290, 0), (295, 0), (300, 0), (305, 0), (310, 0), (315, 0), (320, 0), (325, 0), (330, 0), (335, 0), (340, 0), (345, 0), (350, 0), (355, 1), (360, 1), (365, 1), (370, 1), (375, 1), (380, 1), (385, 1), (390, 1), (395, 1), (400, 1), (405, 1), (410, 1), (415, 1), (420, 1), (425, 1), (430, 1), (435, 1), (440, 1), (445, 1), (450, 1), (455, 1), (460, 1), (465, 1), (470, 0), (475, 0), (480, 0), (485, 0), (490, 0), (495, 0), (500, 0), (505, 0), (510, 0), (515, 0), (520, 0), (525, 1), (530, 1), (535, 1), (540, 1), (545, 1), (550, 1), (555, 1), (560, 1), (565, 1), (570, 1), (575, 1), (580, 1), (585, 1), (590, 1), (595, 1), (600, 1), (605, 1), (610, 1), (615, 1), (620, 0), (625, 0), (630, 0), (635, 0), (640, 0), (645, 1), (650, 1), (655, 1), (660, 1), (665, 0), (670, 0), (675, 0), (680, 1), (685, 1), (690, 1), (695, 1), (700, 1), (705, 1), (710, 0), (715, 1), (720, 1), (725, 1), (730, 1), (735, 1), (740, 1), (745, 1), (750, 1), (755, 1), (760, 0), (765, 0), (770, 0), (775, 0), (780, 0), (785, 1), (790, 0), (795, 0), (800, 0), (805, 0), (810, 0), (815, 0), (820, 0), (825, 0), (830, 0), (835, 0), (840, 0), (845, 0), (850, 0), (855, 0), (860, 0), (865, 1), (870, 1), (875, 0), (880, 0), (885, 0), (890, 1), (895, 1), (900, 0), (905, 0), (910, 0), (915, 0), (920, 0), (925, 0), (930, 0), (935, 0), (940, 0), (945, 0), (950, 0), (955, 0), (960, 0), (965, 0), (970, 0), (975, 1), (980, 1), (985, 1), (990, 1), (995, 1), (1000, 1), (1005, 1), (1010, 1), (1015, 1), (1020, 1), (1025, 1)]
Vdin0_4  din0_4  0 PWL (0n 0.0v 4.745n 0.0v 4.755n 0.0v 9.745n 0.0v 9.755n 0.0v 14.745n 0.0v 14.755n 0.0v 19.745n 0.0v 19.755n 0.0v 24.745n 0.0v 24.755n 0.0v 29.745n 0.0v 29.755n 0.0v 34.745n 0.0v 34.755n 1.1v 39.745n 1.1v 39.755n 1.1v 44.745n 1.1v 44.755n 1.1v 49.745n 1.1v 49.755n 1.1v 54.745n 1.1v 54.755n 1.1v 59.745n 1.1v 59.755n 1.1v 64.745n 1.1v 64.755n 1.1v 69.745n 1.1v 69.755n 1.1v 74.745n 1.1v 74.755n 1.1v 79.745n 1.1v 79.755n 1.1v 84.745n 1.1v 84.755n 1.1v 89.745n 1.1v 89.755n 1.1v 94.745n 1.1v 94.755n 0.0v 99.745n 0.0v 99.755n 0.0v 104.745n 0.0v 104.755n 0.0v 109.745n 0.0v 109.755n 1.1v 114.745n 1.1v 114.755n 1.1v 119.745n 1.1v 119.755n 1.1v 124.745n 1.1v 124.755n 1.1v 129.745n 1.1v 129.755n 0.0v 134.745n 0.0v 134.755n 0.0v 139.745n 0.0v 139.755n 0.0v 144.745n 0.0v 144.755n 0.0v 149.745n 0.0v 149.755n 0.0v 154.745n 0.0v 154.755n 0.0v 159.745n 0.0v 159.755n 0.0v 164.745n 0.0v 164.755n 0.0v 169.745n 0.0v 169.755n 0.0v 174.745n 0.0v 174.755n 0.0v 179.745n 0.0v 179.755n 0.0v 184.745n 0.0v 184.755n 0.0v 189.745n 0.0v 189.755n 0.0v 194.745n 0.0v 194.755n 0.0v 199.745n 0.0v 199.755n 0.0v 204.745n 0.0v 204.755n 0.0v 209.745n 0.0v 209.755n 0.0v 214.745n 0.0v 214.755n 0.0v 219.745n 0.0v 219.755n 0.0v 224.745n 0.0v 224.755n 1.1v 229.745n 1.1v 229.755n 1.1v 234.745n 1.1v 234.755n 1.1v 239.745n 1.1v 239.755n 1.1v 244.745n 1.1v 244.755n 1.1v 249.745n 1.1v 249.755n 1.1v 254.745n 1.1v 254.755n 1.1v 259.745n 1.1v 259.755n 1.1v 264.745n 1.1v 264.755n 0.0v 269.745n 0.0v 269.755n 0.0v 274.745n 0.0v 274.755n 0.0v 279.745n 0.0v 279.755n 0.0v 284.745n 0.0v 284.755n 0.0v 289.745n 0.0v 289.755n 0.0v 294.745n 0.0v 294.755n 0.0v 299.745n 0.0v 299.755n 0.0v 304.745n 0.0v 304.755n 0.0v 309.745n 0.0v 309.755n 0.0v 314.745n 0.0v 314.755n 0.0v 319.745n 0.0v 319.755n 0.0v 324.745n 0.0v 324.755n 0.0v 329.745n 0.0v 329.755n 0.0v 334.745n 0.0v 334.755n 0.0v 339.745n 0.0v 339.755n 0.0v 344.745n 0.0v 344.755n 0.0v 349.745n 0.0v 349.755n 0.0v 354.745n 0.0v 354.755n 1.1v 359.745n 1.1v 359.755n 1.1v 364.745n 1.1v 364.755n 1.1v 369.745n 1.1v 369.755n 1.1v 374.745n 1.1v 374.755n 1.1v 379.745n 1.1v 379.755n 1.1v 384.745n 1.1v 384.755n 1.1v 389.745n 1.1v 389.755n 1.1v 394.745n 1.1v 394.755n 1.1v 399.745n 1.1v 399.755n 1.1v 404.745n 1.1v 404.755n 1.1v 409.745n 1.1v 409.755n 1.1v 414.745n 1.1v 414.755n 1.1v 419.745n 1.1v 419.755n 1.1v 424.745n 1.1v 424.755n 1.1v 429.745n 1.1v 429.755n 1.1v 434.745n 1.1v 434.755n 1.1v 439.745n 1.1v 439.755n 1.1v 444.745n 1.1v 444.755n 1.1v 449.745n 1.1v 449.755n 1.1v 454.745n 1.1v 454.755n 1.1v 459.745n 1.1v 459.755n 1.1v 464.745n 1.1v 464.755n 1.1v 469.745n 1.1v 469.755n 0.0v 474.745n 0.0v 474.755n 0.0v 479.745n 0.0v 479.755n 0.0v 484.745n 0.0v 484.755n 0.0v 489.745n 0.0v 489.755n 0.0v 494.745n 0.0v 494.755n 0.0v 499.745n 0.0v 499.755n 0.0v 504.745n 0.0v 504.755n 0.0v 509.745n 0.0v 509.755n 0.0v 514.745n 0.0v 514.755n 0.0v 519.745n 0.0v 519.755n 0.0v 524.745n 0.0v 524.755n 1.1v 529.745n 1.1v 529.755n 1.1v 534.745n 1.1v 534.755n 1.1v 539.745n 1.1v 539.755n 1.1v 544.745n 1.1v 544.755n 1.1v 549.745n 1.1v 549.755n 1.1v 554.745n 1.1v 554.755n 1.1v 559.745n 1.1v 559.755n 1.1v 564.745n 1.1v 564.755n 1.1v 569.745n 1.1v 569.755n 1.1v 574.745n 1.1v 574.755n 1.1v 579.745n 1.1v 579.755n 1.1v 584.745n 1.1v 584.755n 1.1v 589.745n 1.1v 589.755n 1.1v 594.745n 1.1v 594.755n 1.1v 599.745n 1.1v 599.755n 1.1v 604.745n 1.1v 604.755n 1.1v 609.745n 1.1v 609.755n 1.1v 614.745n 1.1v 614.755n 1.1v 619.745n 1.1v 619.755n 0.0v 624.745n 0.0v 624.755n 0.0v 629.745n 0.0v 629.755n 0.0v 634.745n 0.0v 634.755n 0.0v 639.745n 0.0v 639.755n 0.0v 644.745n 0.0v 644.755n 1.1v 649.745n 1.1v 649.755n 1.1v 654.745n 1.1v 654.755n 1.1v 659.745n 1.1v 659.755n 1.1v 664.745n 1.1v 664.755n 0.0v 669.745n 0.0v 669.755n 0.0v 674.745n 0.0v 674.755n 0.0v 679.745n 0.0v 679.755n 1.1v 684.745n 1.1v 684.755n 1.1v 689.745n 1.1v 689.755n 1.1v 694.745n 1.1v 694.755n 1.1v 699.745n 1.1v 699.755n 1.1v 704.745n 1.1v 704.755n 1.1v 709.745n 1.1v 709.755n 0.0v 714.745n 0.0v 714.755n 1.1v 719.745n 1.1v 719.755n 1.1v 724.745n 1.1v 724.755n 1.1v 729.745n 1.1v 729.755n 1.1v 734.745n 1.1v 734.755n 1.1v 739.745n 1.1v 739.755n 1.1v 744.745n 1.1v 744.755n 1.1v 749.745n 1.1v 749.755n 1.1v 754.745n 1.1v 754.755n 1.1v 759.745n 1.1v 759.755n 0.0v 764.745n 0.0v 764.755n 0.0v 769.745n 0.0v 769.755n 0.0v 774.745n 0.0v 774.755n 0.0v 779.745n 0.0v 779.755n 0.0v 784.745n 0.0v 784.755n 1.1v 789.745n 1.1v 789.755n 0.0v 794.745n 0.0v 794.755n 0.0v 799.745n 0.0v 799.755n 0.0v 804.745n 0.0v 804.755n 0.0v 809.745n 0.0v 809.755n 0.0v 814.745n 0.0v 814.755n 0.0v 819.745n 0.0v 819.755n 0.0v 824.745n 0.0v 824.755n 0.0v 829.745n 0.0v 829.755n 0.0v 834.745n 0.0v 834.755n 0.0v 839.745n 0.0v 839.755n 0.0v 844.745n 0.0v 844.755n 0.0v 849.745n 0.0v 849.755n 0.0v 854.745n 0.0v 854.755n 0.0v 859.745n 0.0v 859.755n 0.0v 864.745n 0.0v 864.755n 1.1v 869.745n 1.1v 869.755n 1.1v 874.745n 1.1v 874.755n 0.0v 879.745n 0.0v 879.755n 0.0v 884.745n 0.0v 884.755n 0.0v 889.745n 0.0v 889.755n 1.1v 894.745n 1.1v 894.755n 1.1v 899.745n 1.1v 899.755n 0.0v 904.745n 0.0v 904.755n 0.0v 909.745n 0.0v 909.755n 0.0v 914.745n 0.0v 914.755n 0.0v 919.745n 0.0v 919.755n 0.0v 924.745n 0.0v 924.755n 0.0v 929.745n 0.0v 929.755n 0.0v 934.745n 0.0v 934.755n 0.0v 939.745n 0.0v 939.755n 0.0v 944.745n 0.0v 944.755n 0.0v 949.745n 0.0v 949.755n 0.0v 954.745n 0.0v 954.755n 0.0v 959.745n 0.0v 959.755n 0.0v 964.745n 0.0v 964.755n 0.0v 969.745n 0.0v 969.755n 0.0v 974.745n 0.0v 974.755n 1.1v 979.745n 1.1v 979.755n 1.1v 984.745n 1.1v 984.755n 1.1v 989.745n 1.1v 989.755n 1.1v 994.745n 1.1v 994.755n 1.1v 999.745n 1.1v 999.755n 1.1v 1004.745n 1.1v 1004.755n 1.1v 1009.745n 1.1v 1009.755n 1.1v 1014.745n 1.1v 1014.755n 1.1v 1019.745n 1.1v 1019.755n 1.1v 1024.745n 1.1v 1024.755n 1.1v )
* (time, data): [(0, 0), (5, 1), (10, 1), (15, 1), (20, 1), (25, 1), (30, 1), (35, 1), (40, 1), (45, 1), (50, 1), (55, 1), (60, 1), (65, 0), (70, 0), (75, 0), (80, 0), (85, 0), (90, 0), (95, 1), (100, 1), (105, 1), (110, 1), (115, 1), (120, 1), (125, 1), (130, 1), (135, 1), (140, 0), (145, 0), (150, 0), (155, 1), (160, 1), (165, 1), (170, 1), (175, 1), (180, 1), (185, 1), (190, 1), (195, 1), (200, 1), (205, 1), (210, 1), (215, 1), (220, 1), (225, 0), (230, 0), (235, 0), (240, 0), (245, 0), (250, 0), (255, 0), (260, 0), (265, 0), (270, 0), (275, 0), (280, 0), (285, 0), (290, 0), (295, 0), (300, 0), (305, 0), (310, 0), (315, 0), (320, 0), (325, 0), (330, 0), (335, 0), (340, 0), (345, 0), (350, 0), (355, 0), (360, 0), (365, 0), (370, 0), (375, 0), (380, 1), (385, 1), (390, 1), (395, 1), (400, 1), (405, 1), (410, 1), (415, 1), (420, 1), (425, 1), (430, 1), (435, 1), (440, 1), (445, 1), (450, 1), (455, 1), (460, 1), (465, 1), (470, 1), (475, 0), (480, 0), (485, 0), (490, 0), (495, 0), (500, 0), (505, 0), (510, 0), (515, 0), (520, 0), (525, 1), (530, 1), (535, 1), (540, 1), (545, 1), (550, 1), (555, 1), (560, 1), (565, 1), (570, 1), (575, 1), (580, 1), (585, 1), (590, 1), (595, 1), (600, 1), (605, 1), (610, 1), (615, 1), (620, 1), (625, 1), (630, 1), (635, 1), (640, 1), (645, 1), (650, 1), (655, 1), (660, 0), (665, 0), (670, 0), (675, 1), (680, 0), (685, 0), (690, 0), (695, 0), (700, 0), (705, 0), (710, 0), (715, 0), (720, 0), (725, 0), (730, 0), (735, 0), (740, 0), (745, 0), (750, 0), (755, 0), (760, 1), (765, 1), (770, 0), (775, 0), (780, 0), (785, 1), (790, 1), (795, 1), (800, 1), (805, 1), (810, 1), (815, 1), (820, 1), (825, 1), (830, 1), (835, 1), (840, 1), (845, 0), (850, 0), (855, 0), (860, 0), (865, 1), (870, 1), (875, 1), (880, 1), (885, 1), (890, 1), (895, 1), (900, 1), (905, 1), (910, 0), (915, 0), (920, 0), (925, 0), (930, 0), (935, 0), (940, 0), (945, 0), (950, 0), (955, 0), (960, 0), (965, 0), (970, 0), (975, 0), (980, 0), (985, 0), (990, 0), (995, 1), (1000, 1), (1005, 1), (1010, 1), (1015, 1), (1020, 1), (1025, 1)]
Vdin0_5  din0_5  0 PWL (0n 0.0v 4.745n 0.0v 4.755n 1.1v 9.745n 1.1v 9.755n 1.1v 14.745n 1.1v 14.755n 1.1v 19.745n 1.1v 19.755n 1.1v 24.745n 1.1v 24.755n 1.1v 29.745n 1.1v 29.755n 1.1v 34.745n 1.1v 34.755n 1.1v 39.745n 1.1v 39.755n 1.1v 44.745n 1.1v 44.755n 1.1v 49.745n 1.1v 49.755n 1.1v 54.745n 1.1v 54.755n 1.1v 59.745n 1.1v 59.755n 1.1v 64.745n 1.1v 64.755n 0.0v 69.745n 0.0v 69.755n 0.0v 74.745n 0.0v 74.755n 0.0v 79.745n 0.0v 79.755n 0.0v 84.745n 0.0v 84.755n 0.0v 89.745n 0.0v 89.755n 0.0v 94.745n 0.0v 94.755n 1.1v 99.745n 1.1v 99.755n 1.1v 104.745n 1.1v 104.755n 1.1v 109.745n 1.1v 109.755n 1.1v 114.745n 1.1v 114.755n 1.1v 119.745n 1.1v 119.755n 1.1v 124.745n 1.1v 124.755n 1.1v 129.745n 1.1v 129.755n 1.1v 134.745n 1.1v 134.755n 1.1v 139.745n 1.1v 139.755n 0.0v 144.745n 0.0v 144.755n 0.0v 149.745n 0.0v 149.755n 0.0v 154.745n 0.0v 154.755n 1.1v 159.745n 1.1v 159.755n 1.1v 164.745n 1.1v 164.755n 1.1v 169.745n 1.1v 169.755n 1.1v 174.745n 1.1v 174.755n 1.1v 179.745n 1.1v 179.755n 1.1v 184.745n 1.1v 184.755n 1.1v 189.745n 1.1v 189.755n 1.1v 194.745n 1.1v 194.755n 1.1v 199.745n 1.1v 199.755n 1.1v 204.745n 1.1v 204.755n 1.1v 209.745n 1.1v 209.755n 1.1v 214.745n 1.1v 214.755n 1.1v 219.745n 1.1v 219.755n 1.1v 224.745n 1.1v 224.755n 0.0v 229.745n 0.0v 229.755n 0.0v 234.745n 0.0v 234.755n 0.0v 239.745n 0.0v 239.755n 0.0v 244.745n 0.0v 244.755n 0.0v 249.745n 0.0v 249.755n 0.0v 254.745n 0.0v 254.755n 0.0v 259.745n 0.0v 259.755n 0.0v 264.745n 0.0v 264.755n 0.0v 269.745n 0.0v 269.755n 0.0v 274.745n 0.0v 274.755n 0.0v 279.745n 0.0v 279.755n 0.0v 284.745n 0.0v 284.755n 0.0v 289.745n 0.0v 289.755n 0.0v 294.745n 0.0v 294.755n 0.0v 299.745n 0.0v 299.755n 0.0v 304.745n 0.0v 304.755n 0.0v 309.745n 0.0v 309.755n 0.0v 314.745n 0.0v 314.755n 0.0v 319.745n 0.0v 319.755n 0.0v 324.745n 0.0v 324.755n 0.0v 329.745n 0.0v 329.755n 0.0v 334.745n 0.0v 334.755n 0.0v 339.745n 0.0v 339.755n 0.0v 344.745n 0.0v 344.755n 0.0v 349.745n 0.0v 349.755n 0.0v 354.745n 0.0v 354.755n 0.0v 359.745n 0.0v 359.755n 0.0v 364.745n 0.0v 364.755n 0.0v 369.745n 0.0v 369.755n 0.0v 374.745n 0.0v 374.755n 0.0v 379.745n 0.0v 379.755n 1.1v 384.745n 1.1v 384.755n 1.1v 389.745n 1.1v 389.755n 1.1v 394.745n 1.1v 394.755n 1.1v 399.745n 1.1v 399.755n 1.1v 404.745n 1.1v 404.755n 1.1v 409.745n 1.1v 409.755n 1.1v 414.745n 1.1v 414.755n 1.1v 419.745n 1.1v 419.755n 1.1v 424.745n 1.1v 424.755n 1.1v 429.745n 1.1v 429.755n 1.1v 434.745n 1.1v 434.755n 1.1v 439.745n 1.1v 439.755n 1.1v 444.745n 1.1v 444.755n 1.1v 449.745n 1.1v 449.755n 1.1v 454.745n 1.1v 454.755n 1.1v 459.745n 1.1v 459.755n 1.1v 464.745n 1.1v 464.755n 1.1v 469.745n 1.1v 469.755n 1.1v 474.745n 1.1v 474.755n 0.0v 479.745n 0.0v 479.755n 0.0v 484.745n 0.0v 484.755n 0.0v 489.745n 0.0v 489.755n 0.0v 494.745n 0.0v 494.755n 0.0v 499.745n 0.0v 499.755n 0.0v 504.745n 0.0v 504.755n 0.0v 509.745n 0.0v 509.755n 0.0v 514.745n 0.0v 514.755n 0.0v 519.745n 0.0v 519.755n 0.0v 524.745n 0.0v 524.755n 1.1v 529.745n 1.1v 529.755n 1.1v 534.745n 1.1v 534.755n 1.1v 539.745n 1.1v 539.755n 1.1v 544.745n 1.1v 544.755n 1.1v 549.745n 1.1v 549.755n 1.1v 554.745n 1.1v 554.755n 1.1v 559.745n 1.1v 559.755n 1.1v 564.745n 1.1v 564.755n 1.1v 569.745n 1.1v 569.755n 1.1v 574.745n 1.1v 574.755n 1.1v 579.745n 1.1v 579.755n 1.1v 584.745n 1.1v 584.755n 1.1v 589.745n 1.1v 589.755n 1.1v 594.745n 1.1v 594.755n 1.1v 599.745n 1.1v 599.755n 1.1v 604.745n 1.1v 604.755n 1.1v 609.745n 1.1v 609.755n 1.1v 614.745n 1.1v 614.755n 1.1v 619.745n 1.1v 619.755n 1.1v 624.745n 1.1v 624.755n 1.1v 629.745n 1.1v 629.755n 1.1v 634.745n 1.1v 634.755n 1.1v 639.745n 1.1v 639.755n 1.1v 644.745n 1.1v 644.755n 1.1v 649.745n 1.1v 649.755n 1.1v 654.745n 1.1v 654.755n 1.1v 659.745n 1.1v 659.755n 0.0v 664.745n 0.0v 664.755n 0.0v 669.745n 0.0v 669.755n 0.0v 674.745n 0.0v 674.755n 1.1v 679.745n 1.1v 679.755n 0.0v 684.745n 0.0v 684.755n 0.0v 689.745n 0.0v 689.755n 0.0v 694.745n 0.0v 694.755n 0.0v 699.745n 0.0v 699.755n 0.0v 704.745n 0.0v 704.755n 0.0v 709.745n 0.0v 709.755n 0.0v 714.745n 0.0v 714.755n 0.0v 719.745n 0.0v 719.755n 0.0v 724.745n 0.0v 724.755n 0.0v 729.745n 0.0v 729.755n 0.0v 734.745n 0.0v 734.755n 0.0v 739.745n 0.0v 739.755n 0.0v 744.745n 0.0v 744.755n 0.0v 749.745n 0.0v 749.755n 0.0v 754.745n 0.0v 754.755n 0.0v 759.745n 0.0v 759.755n 1.1v 764.745n 1.1v 764.755n 1.1v 769.745n 1.1v 769.755n 0.0v 774.745n 0.0v 774.755n 0.0v 779.745n 0.0v 779.755n 0.0v 784.745n 0.0v 784.755n 1.1v 789.745n 1.1v 789.755n 1.1v 794.745n 1.1v 794.755n 1.1v 799.745n 1.1v 799.755n 1.1v 804.745n 1.1v 804.755n 1.1v 809.745n 1.1v 809.755n 1.1v 814.745n 1.1v 814.755n 1.1v 819.745n 1.1v 819.755n 1.1v 824.745n 1.1v 824.755n 1.1v 829.745n 1.1v 829.755n 1.1v 834.745n 1.1v 834.755n 1.1v 839.745n 1.1v 839.755n 1.1v 844.745n 1.1v 844.755n 0.0v 849.745n 0.0v 849.755n 0.0v 854.745n 0.0v 854.755n 0.0v 859.745n 0.0v 859.755n 0.0v 864.745n 0.0v 864.755n 1.1v 869.745n 1.1v 869.755n 1.1v 874.745n 1.1v 874.755n 1.1v 879.745n 1.1v 879.755n 1.1v 884.745n 1.1v 884.755n 1.1v 889.745n 1.1v 889.755n 1.1v 894.745n 1.1v 894.755n 1.1v 899.745n 1.1v 899.755n 1.1v 904.745n 1.1v 904.755n 1.1v 909.745n 1.1v 909.755n 0.0v 914.745n 0.0v 914.755n 0.0v 919.745n 0.0v 919.755n 0.0v 924.745n 0.0v 924.755n 0.0v 929.745n 0.0v 929.755n 0.0v 934.745n 0.0v 934.755n 0.0v 939.745n 0.0v 939.755n 0.0v 944.745n 0.0v 944.755n 0.0v 949.745n 0.0v 949.755n 0.0v 954.745n 0.0v 954.755n 0.0v 959.745n 0.0v 959.755n 0.0v 964.745n 0.0v 964.755n 0.0v 969.745n 0.0v 969.755n 0.0v 974.745n 0.0v 974.755n 0.0v 979.745n 0.0v 979.755n 0.0v 984.745n 0.0v 984.755n 0.0v 989.745n 0.0v 989.755n 0.0v 994.745n 0.0v 994.755n 1.1v 999.745n 1.1v 999.755n 1.1v 1004.745n 1.1v 1004.755n 1.1v 1009.745n 1.1v 1009.755n 1.1v 1014.745n 1.1v 1014.755n 1.1v 1019.745n 1.1v 1019.755n 1.1v 1024.745n 1.1v 1024.755n 1.1v )
* (time, data): [(0, 0), (5, 1), (10, 1), (15, 0), (20, 0), (25, 0), (30, 0), (35, 1), (40, 1), (45, 1), (50, 1), (55, 1), (60, 1), (65, 0), (70, 0), (75, 0), (80, 1), (85, 1), (90, 1), (95, 0), (100, 0), (105, 0), (110, 0), (115, 0), (120, 0), (125, 0), (130, 0), (135, 0), (140, 1), (145, 1), (150, 0), (155, 1), (160, 1), (165, 1), (170, 1), (175, 1), (180, 1), (185, 1), (190, 1), (195, 1), (200, 1), (205, 1), (210, 1), (215, 1), (220, 1), (225, 1), (230, 1), (235, 1), (240, 1), (245, 1), (250, 1), (255, 1), (260, 1), (265, 1), (270, 1), (275, 1), (280, 1), (285, 1), (290, 1), (295, 1), (300, 1), (305, 1), (310, 1), (315, 1), (320, 1), (325, 1), (330, 1), (335, 1), (340, 1), (345, 1), (350, 1), (355, 1), (360, 1), (365, 1), (370, 1), (375, 1), (380, 1), (385, 1), (390, 1), (395, 1), (400, 1), (405, 1), (410, 1), (415, 1), (420, 0), (425, 0), (430, 0), (435, 0), (440, 0), (445, 0), (450, 0), (455, 0), (460, 0), (465, 0), (470, 1), (475, 1), (480, 1), (485, 1), (490, 1), (495, 0), (500, 0), (505, 0), (510, 0), (515, 0), (520, 1), (525, 0), (530, 0), (535, 0), (540, 0), (545, 0), (550, 0), (555, 0), (560, 0), (565, 0), (570, 0), (575, 0), (580, 0), (585, 0), (590, 0), (595, 0), (600, 0), (605, 0), (610, 0), (615, 0), (620, 1), (625, 1), (630, 1), (635, 1), (640, 1), (645, 0), (650, 0), (655, 0), (660, 1), (665, 0), (670, 0), (675, 1), (680, 0), (685, 0), (690, 0), (695, 0), (700, 0), (705, 0), (710, 0), (715, 0), (720, 0), (725, 0), (730, 0), (735, 0), (740, 0), (745, 0), (750, 0), (755, 0), (760, 0), (765, 0), (770, 1), (775, 1), (780, 1), (785, 1), (790, 1), (795, 1), (800, 1), (805, 1), (810, 1), (815, 1), (820, 1), (825, 1), (830, 1), (835, 1), (840, 1), (845, 0), (850, 0), (855, 0), (860, 1), (865, 1), (870, 1), (875, 0), (880, 0), (885, 0), (890, 1), (895, 1), (900, 0), (905, 0), (910, 0), (915, 0), (920, 0), (925, 0), (930, 0), (935, 0), (940, 0), (945, 0), (950, 0), (955, 0), (960, 0), (965, 0), (970, 0), (975, 0), (980, 0), (985, 0), (990, 0), (995, 1), (1000, 1), (1005, 1), (1010, 1), (1015, 1), (1020, 1), (1025, 1)]
Vdin0_6  din0_6  0 PWL (0n 0.0v 4.745n 0.0v 4.755n 1.1v 9.745n 1.1v 9.755n 1.1v 14.745n 1.1v 14.755n 0.0v 19.745n 0.0v 19.755n 0.0v 24.745n 0.0v 24.755n 0.0v 29.745n 0.0v 29.755n 0.0v 34.745n 0.0v 34.755n 1.1v 39.745n 1.1v 39.755n 1.1v 44.745n 1.1v 44.755n 1.1v 49.745n 1.1v 49.755n 1.1v 54.745n 1.1v 54.755n 1.1v 59.745n 1.1v 59.755n 1.1v 64.745n 1.1v 64.755n 0.0v 69.745n 0.0v 69.755n 0.0v 74.745n 0.0v 74.755n 0.0v 79.745n 0.0v 79.755n 1.1v 84.745n 1.1v 84.755n 1.1v 89.745n 1.1v 89.755n 1.1v 94.745n 1.1v 94.755n 0.0v 99.745n 0.0v 99.755n 0.0v 104.745n 0.0v 104.755n 0.0v 109.745n 0.0v 109.755n 0.0v 114.745n 0.0v 114.755n 0.0v 119.745n 0.0v 119.755n 0.0v 124.745n 0.0v 124.755n 0.0v 129.745n 0.0v 129.755n 0.0v 134.745n 0.0v 134.755n 0.0v 139.745n 0.0v 139.755n 1.1v 144.745n 1.1v 144.755n 1.1v 149.745n 1.1v 149.755n 0.0v 154.745n 0.0v 154.755n 1.1v 159.745n 1.1v 159.755n 1.1v 164.745n 1.1v 164.755n 1.1v 169.745n 1.1v 169.755n 1.1v 174.745n 1.1v 174.755n 1.1v 179.745n 1.1v 179.755n 1.1v 184.745n 1.1v 184.755n 1.1v 189.745n 1.1v 189.755n 1.1v 194.745n 1.1v 194.755n 1.1v 199.745n 1.1v 199.755n 1.1v 204.745n 1.1v 204.755n 1.1v 209.745n 1.1v 209.755n 1.1v 214.745n 1.1v 214.755n 1.1v 219.745n 1.1v 219.755n 1.1v 224.745n 1.1v 224.755n 1.1v 229.745n 1.1v 229.755n 1.1v 234.745n 1.1v 234.755n 1.1v 239.745n 1.1v 239.755n 1.1v 244.745n 1.1v 244.755n 1.1v 249.745n 1.1v 249.755n 1.1v 254.745n 1.1v 254.755n 1.1v 259.745n 1.1v 259.755n 1.1v 264.745n 1.1v 264.755n 1.1v 269.745n 1.1v 269.755n 1.1v 274.745n 1.1v 274.755n 1.1v 279.745n 1.1v 279.755n 1.1v 284.745n 1.1v 284.755n 1.1v 289.745n 1.1v 289.755n 1.1v 294.745n 1.1v 294.755n 1.1v 299.745n 1.1v 299.755n 1.1v 304.745n 1.1v 304.755n 1.1v 309.745n 1.1v 309.755n 1.1v 314.745n 1.1v 314.755n 1.1v 319.745n 1.1v 319.755n 1.1v 324.745n 1.1v 324.755n 1.1v 329.745n 1.1v 329.755n 1.1v 334.745n 1.1v 334.755n 1.1v 339.745n 1.1v 339.755n 1.1v 344.745n 1.1v 344.755n 1.1v 349.745n 1.1v 349.755n 1.1v 354.745n 1.1v 354.755n 1.1v 359.745n 1.1v 359.755n 1.1v 364.745n 1.1v 364.755n 1.1v 369.745n 1.1v 369.755n 1.1v 374.745n 1.1v 374.755n 1.1v 379.745n 1.1v 379.755n 1.1v 384.745n 1.1v 384.755n 1.1v 389.745n 1.1v 389.755n 1.1v 394.745n 1.1v 394.755n 1.1v 399.745n 1.1v 399.755n 1.1v 404.745n 1.1v 404.755n 1.1v 409.745n 1.1v 409.755n 1.1v 414.745n 1.1v 414.755n 1.1v 419.745n 1.1v 419.755n 0.0v 424.745n 0.0v 424.755n 0.0v 429.745n 0.0v 429.755n 0.0v 434.745n 0.0v 434.755n 0.0v 439.745n 0.0v 439.755n 0.0v 444.745n 0.0v 444.755n 0.0v 449.745n 0.0v 449.755n 0.0v 454.745n 0.0v 454.755n 0.0v 459.745n 0.0v 459.755n 0.0v 464.745n 0.0v 464.755n 0.0v 469.745n 0.0v 469.755n 1.1v 474.745n 1.1v 474.755n 1.1v 479.745n 1.1v 479.755n 1.1v 484.745n 1.1v 484.755n 1.1v 489.745n 1.1v 489.755n 1.1v 494.745n 1.1v 494.755n 0.0v 499.745n 0.0v 499.755n 0.0v 504.745n 0.0v 504.755n 0.0v 509.745n 0.0v 509.755n 0.0v 514.745n 0.0v 514.755n 0.0v 519.745n 0.0v 519.755n 1.1v 524.745n 1.1v 524.755n 0.0v 529.745n 0.0v 529.755n 0.0v 534.745n 0.0v 534.755n 0.0v 539.745n 0.0v 539.755n 0.0v 544.745n 0.0v 544.755n 0.0v 549.745n 0.0v 549.755n 0.0v 554.745n 0.0v 554.755n 0.0v 559.745n 0.0v 559.755n 0.0v 564.745n 0.0v 564.755n 0.0v 569.745n 0.0v 569.755n 0.0v 574.745n 0.0v 574.755n 0.0v 579.745n 0.0v 579.755n 0.0v 584.745n 0.0v 584.755n 0.0v 589.745n 0.0v 589.755n 0.0v 594.745n 0.0v 594.755n 0.0v 599.745n 0.0v 599.755n 0.0v 604.745n 0.0v 604.755n 0.0v 609.745n 0.0v 609.755n 0.0v 614.745n 0.0v 614.755n 0.0v 619.745n 0.0v 619.755n 1.1v 624.745n 1.1v 624.755n 1.1v 629.745n 1.1v 629.755n 1.1v 634.745n 1.1v 634.755n 1.1v 639.745n 1.1v 639.755n 1.1v 644.745n 1.1v 644.755n 0.0v 649.745n 0.0v 649.755n 0.0v 654.745n 0.0v 654.755n 0.0v 659.745n 0.0v 659.755n 1.1v 664.745n 1.1v 664.755n 0.0v 669.745n 0.0v 669.755n 0.0v 674.745n 0.0v 674.755n 1.1v 679.745n 1.1v 679.755n 0.0v 684.745n 0.0v 684.755n 0.0v 689.745n 0.0v 689.755n 0.0v 694.745n 0.0v 694.755n 0.0v 699.745n 0.0v 699.755n 0.0v 704.745n 0.0v 704.755n 0.0v 709.745n 0.0v 709.755n 0.0v 714.745n 0.0v 714.755n 0.0v 719.745n 0.0v 719.755n 0.0v 724.745n 0.0v 724.755n 0.0v 729.745n 0.0v 729.755n 0.0v 734.745n 0.0v 734.755n 0.0v 739.745n 0.0v 739.755n 0.0v 744.745n 0.0v 744.755n 0.0v 749.745n 0.0v 749.755n 0.0v 754.745n 0.0v 754.755n 0.0v 759.745n 0.0v 759.755n 0.0v 764.745n 0.0v 764.755n 0.0v 769.745n 0.0v 769.755n 1.1v 774.745n 1.1v 774.755n 1.1v 779.745n 1.1v 779.755n 1.1v 784.745n 1.1v 784.755n 1.1v 789.745n 1.1v 789.755n 1.1v 794.745n 1.1v 794.755n 1.1v 799.745n 1.1v 799.755n 1.1v 804.745n 1.1v 804.755n 1.1v 809.745n 1.1v 809.755n 1.1v 814.745n 1.1v 814.755n 1.1v 819.745n 1.1v 819.755n 1.1v 824.745n 1.1v 824.755n 1.1v 829.745n 1.1v 829.755n 1.1v 834.745n 1.1v 834.755n 1.1v 839.745n 1.1v 839.755n 1.1v 844.745n 1.1v 844.755n 0.0v 849.745n 0.0v 849.755n 0.0v 854.745n 0.0v 854.755n 0.0v 859.745n 0.0v 859.755n 1.1v 864.745n 1.1v 864.755n 1.1v 869.745n 1.1v 869.755n 1.1v 874.745n 1.1v 874.755n 0.0v 879.745n 0.0v 879.755n 0.0v 884.745n 0.0v 884.755n 0.0v 889.745n 0.0v 889.755n 1.1v 894.745n 1.1v 894.755n 1.1v 899.745n 1.1v 899.755n 0.0v 904.745n 0.0v 904.755n 0.0v 909.745n 0.0v 909.755n 0.0v 914.745n 0.0v 914.755n 0.0v 919.745n 0.0v 919.755n 0.0v 924.745n 0.0v 924.755n 0.0v 929.745n 0.0v 929.755n 0.0v 934.745n 0.0v 934.755n 0.0v 939.745n 0.0v 939.755n 0.0v 944.745n 0.0v 944.755n 0.0v 949.745n 0.0v 949.755n 0.0v 954.745n 0.0v 954.755n 0.0v 959.745n 0.0v 959.755n 0.0v 964.745n 0.0v 964.755n 0.0v 969.745n 0.0v 969.755n 0.0v 974.745n 0.0v 974.755n 0.0v 979.745n 0.0v 979.755n 0.0v 984.745n 0.0v 984.755n 0.0v 989.745n 0.0v 989.755n 0.0v 994.745n 0.0v 994.755n 1.1v 999.745n 1.1v 999.755n 1.1v 1004.745n 1.1v 1004.755n 1.1v 1009.745n 1.1v 1009.755n 1.1v 1014.745n 1.1v 1014.755n 1.1v 1019.745n 1.1v 1019.755n 1.1v 1024.745n 1.1v 1024.755n 1.1v )
* (time, data): [(0, 0), (5, 1), (10, 1), (15, 1), (20, 1), (25, 1), (30, 0), (35, 1), (40, 1), (45, 1), (50, 1), (55, 1), (60, 0), (65, 0), (70, 0), (75, 0), (80, 0), (85, 0), (90, 0), (95, 0), (100, 0), (105, 0), (110, 1), (115, 1), (120, 1), (125, 1), (130, 0), (135, 0), (140, 1), (145, 1), (150, 0), (155, 0), (160, 0), (165, 0), (170, 0), (175, 0), (180, 0), (185, 0), (190, 0), (195, 0), (200, 0), (205, 0), (210, 0), (215, 0), (220, 0), (225, 0), (230, 0), (235, 0), (240, 0), (245, 0), (250, 0), (255, 0), (260, 0), (265, 1), (270, 0), (275, 0), (280, 0), (285, 0), (290, 0), (295, 0), (300, 0), (305, 0), (310, 0), (315, 0), (320, 0), (325, 0), (330, 0), (335, 0), (340, 0), (345, 0), (350, 0), (355, 0), (360, 0), (365, 0), (370, 0), (375, 0), (380, 0), (385, 0), (390, 0), (395, 0), (400, 0), (405, 0), (410, 0), (415, 0), (420, 1), (425, 1), (430, 1), (435, 1), (440, 1), (445, 1), (450, 1), (455, 1), (460, 1), (465, 1), (470, 0), (475, 0), (480, 0), (485, 0), (490, 0), (495, 0), (500, 0), (505, 0), (510, 0), (515, 0), (520, 1), (525, 0), (530, 0), (535, 0), (540, 0), (545, 0), (550, 0), (555, 0), (560, 0), (565, 0), (570, 0), (575, 0), (580, 0), (585, 0), (590, 0), (595, 0), (600, 0), (605, 0), (610, 0), (615, 0), (620, 1), (625, 1), (630, 1), (635, 1), (640, 1), (645, 0), (650, 0), (655, 0), (660, 1), (665, 1), (670, 1), (675, 1), (680, 1), (685, 1), (690, 1), (695, 1), (700, 1), (705, 1), (710, 1), (715, 1), (720, 1), (725, 1), (730, 1), (735, 1), (740, 0), (745, 0), (750, 0), (755, 0), (760, 0), (765, 0), (770, 1), (775, 1), (780, 1), (785, 1), (790, 1), (795, 0), (800, 0), (805, 0), (810, 0), (815, 0), (820, 0), (825, 0), (830, 0), (835, 0), (840, 0), (845, 0), (850, 0), (855, 0), (860, 1), (865, 1), (870, 1), (875, 1), (880, 1), (885, 1), (890, 0), (895, 0), (900, 0), (905, 0), (910, 1), (915, 1), (920, 1), (925, 1), (930, 1), (935, 1), (940, 1), (945, 1), (950, 1), (955, 1), (960, 1), (965, 1), (970, 1), (975, 0), (980, 0), (985, 0), (990, 0), (995, 0), (1000, 0), (1005, 1), (1010, 1), (1015, 1), (1020, 1), (1025, 1)]
Vdin0_7  din0_7  0 PWL (0n 0.0v 4.745n 0.0v 4.755n 1.1v 9.745n 1.1v 9.755n 1.1v 14.745n 1.1v 14.755n 1.1v 19.745n 1.1v 19.755n 1.1v 24.745n 1.1v 24.755n 1.1v 29.745n 1.1v 29.755n 0.0v 34.745n 0.0v 34.755n 1.1v 39.745n 1.1v 39.755n 1.1v 44.745n 1.1v 44.755n 1.1v 49.745n 1.1v 49.755n 1.1v 54.745n 1.1v 54.755n 1.1v 59.745n 1.1v 59.755n 0.0v 64.745n 0.0v 64.755n 0.0v 69.745n 0.0v 69.755n 0.0v 74.745n 0.0v 74.755n 0.0v 79.745n 0.0v 79.755n 0.0v 84.745n 0.0v 84.755n 0.0v 89.745n 0.0v 89.755n 0.0v 94.745n 0.0v 94.755n 0.0v 99.745n 0.0v 99.755n 0.0v 104.745n 0.0v 104.755n 0.0v 109.745n 0.0v 109.755n 1.1v 114.745n 1.1v 114.755n 1.1v 119.745n 1.1v 119.755n 1.1v 124.745n 1.1v 124.755n 1.1v 129.745n 1.1v 129.755n 0.0v 134.745n 0.0v 134.755n 0.0v 139.745n 0.0v 139.755n 1.1v 144.745n 1.1v 144.755n 1.1v 149.745n 1.1v 149.755n 0.0v 154.745n 0.0v 154.755n 0.0v 159.745n 0.0v 159.755n 0.0v 164.745n 0.0v 164.755n 0.0v 169.745n 0.0v 169.755n 0.0v 174.745n 0.0v 174.755n 0.0v 179.745n 0.0v 179.755n 0.0v 184.745n 0.0v 184.755n 0.0v 189.745n 0.0v 189.755n 0.0v 194.745n 0.0v 194.755n 0.0v 199.745n 0.0v 199.755n 0.0v 204.745n 0.0v 204.755n 0.0v 209.745n 0.0v 209.755n 0.0v 214.745n 0.0v 214.755n 0.0v 219.745n 0.0v 219.755n 0.0v 224.745n 0.0v 224.755n 0.0v 229.745n 0.0v 229.755n 0.0v 234.745n 0.0v 234.755n 0.0v 239.745n 0.0v 239.755n 0.0v 244.745n 0.0v 244.755n 0.0v 249.745n 0.0v 249.755n 0.0v 254.745n 0.0v 254.755n 0.0v 259.745n 0.0v 259.755n 0.0v 264.745n 0.0v 264.755n 1.1v 269.745n 1.1v 269.755n 0.0v 274.745n 0.0v 274.755n 0.0v 279.745n 0.0v 279.755n 0.0v 284.745n 0.0v 284.755n 0.0v 289.745n 0.0v 289.755n 0.0v 294.745n 0.0v 294.755n 0.0v 299.745n 0.0v 299.755n 0.0v 304.745n 0.0v 304.755n 0.0v 309.745n 0.0v 309.755n 0.0v 314.745n 0.0v 314.755n 0.0v 319.745n 0.0v 319.755n 0.0v 324.745n 0.0v 324.755n 0.0v 329.745n 0.0v 329.755n 0.0v 334.745n 0.0v 334.755n 0.0v 339.745n 0.0v 339.755n 0.0v 344.745n 0.0v 344.755n 0.0v 349.745n 0.0v 349.755n 0.0v 354.745n 0.0v 354.755n 0.0v 359.745n 0.0v 359.755n 0.0v 364.745n 0.0v 364.755n 0.0v 369.745n 0.0v 369.755n 0.0v 374.745n 0.0v 374.755n 0.0v 379.745n 0.0v 379.755n 0.0v 384.745n 0.0v 384.755n 0.0v 389.745n 0.0v 389.755n 0.0v 394.745n 0.0v 394.755n 0.0v 399.745n 0.0v 399.755n 0.0v 404.745n 0.0v 404.755n 0.0v 409.745n 0.0v 409.755n 0.0v 414.745n 0.0v 414.755n 0.0v 419.745n 0.0v 419.755n 1.1v 424.745n 1.1v 424.755n 1.1v 429.745n 1.1v 429.755n 1.1v 434.745n 1.1v 434.755n 1.1v 439.745n 1.1v 439.755n 1.1v 444.745n 1.1v 444.755n 1.1v 449.745n 1.1v 449.755n 1.1v 454.745n 1.1v 454.755n 1.1v 459.745n 1.1v 459.755n 1.1v 464.745n 1.1v 464.755n 1.1v 469.745n 1.1v 469.755n 0.0v 474.745n 0.0v 474.755n 0.0v 479.745n 0.0v 479.755n 0.0v 484.745n 0.0v 484.755n 0.0v 489.745n 0.0v 489.755n 0.0v 494.745n 0.0v 494.755n 0.0v 499.745n 0.0v 499.755n 0.0v 504.745n 0.0v 504.755n 0.0v 509.745n 0.0v 509.755n 0.0v 514.745n 0.0v 514.755n 0.0v 519.745n 0.0v 519.755n 1.1v 524.745n 1.1v 524.755n 0.0v 529.745n 0.0v 529.755n 0.0v 534.745n 0.0v 534.755n 0.0v 539.745n 0.0v 539.755n 0.0v 544.745n 0.0v 544.755n 0.0v 549.745n 0.0v 549.755n 0.0v 554.745n 0.0v 554.755n 0.0v 559.745n 0.0v 559.755n 0.0v 564.745n 0.0v 564.755n 0.0v 569.745n 0.0v 569.755n 0.0v 574.745n 0.0v 574.755n 0.0v 579.745n 0.0v 579.755n 0.0v 584.745n 0.0v 584.755n 0.0v 589.745n 0.0v 589.755n 0.0v 594.745n 0.0v 594.755n 0.0v 599.745n 0.0v 599.755n 0.0v 604.745n 0.0v 604.755n 0.0v 609.745n 0.0v 609.755n 0.0v 614.745n 0.0v 614.755n 0.0v 619.745n 0.0v 619.755n 1.1v 624.745n 1.1v 624.755n 1.1v 629.745n 1.1v 629.755n 1.1v 634.745n 1.1v 634.755n 1.1v 639.745n 1.1v 639.755n 1.1v 644.745n 1.1v 644.755n 0.0v 649.745n 0.0v 649.755n 0.0v 654.745n 0.0v 654.755n 0.0v 659.745n 0.0v 659.755n 1.1v 664.745n 1.1v 664.755n 1.1v 669.745n 1.1v 669.755n 1.1v 674.745n 1.1v 674.755n 1.1v 679.745n 1.1v 679.755n 1.1v 684.745n 1.1v 684.755n 1.1v 689.745n 1.1v 689.755n 1.1v 694.745n 1.1v 694.755n 1.1v 699.745n 1.1v 699.755n 1.1v 704.745n 1.1v 704.755n 1.1v 709.745n 1.1v 709.755n 1.1v 714.745n 1.1v 714.755n 1.1v 719.745n 1.1v 719.755n 1.1v 724.745n 1.1v 724.755n 1.1v 729.745n 1.1v 729.755n 1.1v 734.745n 1.1v 734.755n 1.1v 739.745n 1.1v 739.755n 0.0v 744.745n 0.0v 744.755n 0.0v 749.745n 0.0v 749.755n 0.0v 754.745n 0.0v 754.755n 0.0v 759.745n 0.0v 759.755n 0.0v 764.745n 0.0v 764.755n 0.0v 769.745n 0.0v 769.755n 1.1v 774.745n 1.1v 774.755n 1.1v 779.745n 1.1v 779.755n 1.1v 784.745n 1.1v 784.755n 1.1v 789.745n 1.1v 789.755n 1.1v 794.745n 1.1v 794.755n 0.0v 799.745n 0.0v 799.755n 0.0v 804.745n 0.0v 804.755n 0.0v 809.745n 0.0v 809.755n 0.0v 814.745n 0.0v 814.755n 0.0v 819.745n 0.0v 819.755n 0.0v 824.745n 0.0v 824.755n 0.0v 829.745n 0.0v 829.755n 0.0v 834.745n 0.0v 834.755n 0.0v 839.745n 0.0v 839.755n 0.0v 844.745n 0.0v 844.755n 0.0v 849.745n 0.0v 849.755n 0.0v 854.745n 0.0v 854.755n 0.0v 859.745n 0.0v 859.755n 1.1v 864.745n 1.1v 864.755n 1.1v 869.745n 1.1v 869.755n 1.1v 874.745n 1.1v 874.755n 1.1v 879.745n 1.1v 879.755n 1.1v 884.745n 1.1v 884.755n 1.1v 889.745n 1.1v 889.755n 0.0v 894.745n 0.0v 894.755n 0.0v 899.745n 0.0v 899.755n 0.0v 904.745n 0.0v 904.755n 0.0v 909.745n 0.0v 909.755n 1.1v 914.745n 1.1v 914.755n 1.1v 919.745n 1.1v 919.755n 1.1v 924.745n 1.1v 924.755n 1.1v 929.745n 1.1v 929.755n 1.1v 934.745n 1.1v 934.755n 1.1v 939.745n 1.1v 939.755n 1.1v 944.745n 1.1v 944.755n 1.1v 949.745n 1.1v 949.755n 1.1v 954.745n 1.1v 954.755n 1.1v 959.745n 1.1v 959.755n 1.1v 964.745n 1.1v 964.755n 1.1v 969.745n 1.1v 969.755n 1.1v 974.745n 1.1v 974.755n 0.0v 979.745n 0.0v 979.755n 0.0v 984.745n 0.0v 984.755n 0.0v 989.745n 0.0v 989.755n 0.0v 994.745n 0.0v 994.755n 0.0v 999.745n 0.0v 999.755n 0.0v 1004.745n 0.0v 1004.755n 1.1v 1009.745n 1.1v 1009.755n 1.1v 1014.745n 1.1v 1014.755n 1.1v 1019.745n 1.1v 1019.755n 1.1v 1024.745n 1.1v 1024.755n 1.1v )
* (time, data): [(0, 0), (5, 0), (10, 0), (15, 0), (20, 0), (25, 0), (30, 1), (35, 1), (40, 1), (45, 1), (50, 1), (55, 1), (60, 1), (65, 1), (70, 1), (75, 1), (80, 1), (85, 1), (90, 1), (95, 0), (100, 0), (105, 0), (110, 1), (115, 0), (120, 0), (125, 0), (130, 1), (135, 1), (140, 1), (145, 1), (150, 0), (155, 0), (160, 0), (165, 0), (170, 0), (175, 0), (180, 0), (185, 0), (190, 0), (195, 0), (200, 0), (205, 0), (210, 0), (215, 0), (220, 0), (225, 1), (230, 1), (235, 1), (240, 1), (245, 1), (250, 1), (255, 1), (260, 1), (265, 0), (270, 1), (275, 1), (280, 1), (285, 1), (290, 1), (295, 1), (300, 1), (305, 1), (310, 1), (315, 1), (320, 1), (325, 1), (330, 1), (335, 1), (340, 1), (345, 1), (350, 1), (355, 1), (360, 1), (365, 1), (370, 1), (375, 1), (380, 1), (385, 1), (390, 1), (395, 1), (400, 1), (405, 1), (410, 1), (415, 1), (420, 1), (425, 1), (430, 1), (435, 1), (440, 1), (445, 1), (450, 1), (455, 1), (460, 1), (465, 1), (470, 1), (475, 0), (480, 0), (485, 0), (490, 0), (495, 1), (500, 1), (505, 1), (510, 1), (515, 1), (520, 0), (525, 0), (530, 0), (535, 0), (540, 0), (545, 0), (550, 0), (555, 0), (560, 0), (565, 0), (570, 0), (575, 0), (580, 0), (585, 0), (590, 0), (595, 0), (600, 0), (605, 0), (610, 0), (615, 0), (620, 1), (625, 1), (630, 1), (635, 1), (640, 1), (645, 1), (650, 1), (655, 1), (660, 0), (665, 0), (670, 0), (675, 1), (680, 0), (685, 0), (690, 0), (695, 0), (700, 0), (705, 0), (710, 1), (715, 0), (720, 0), (725, 0), (730, 0), (735, 0), (740, 1), (745, 1), (750, 1), (755, 1), (760, 0), (765, 0), (770, 1), (775, 1), (780, 1), (785, 0), (790, 1), (795, 0), (800, 0), (805, 0), (810, 0), (815, 0), (820, 0), (825, 0), (830, 0), (835, 0), (840, 0), (845, 0), (850, 0), (855, 0), (860, 1), (865, 1), (870, 1), (875, 1), (880, 1), (885, 1), (890, 0), (895, 0), (900, 1), (905, 1), (910, 1), (915, 1), (920, 1), (925, 1), (930, 1), (935, 1), (940, 1), (945, 1), (950, 1), (955, 1), (960, 1), (965, 1), (970, 1), (975, 1), (980, 1), (985, 1), (990, 1), (995, 0), (1000, 0), (1005, 1), (1010, 1), (1015, 1), (1020, 1), (1025, 1)]
Vdin0_8  din0_8  0 PWL (0n 0.0v 4.745n 0.0v 4.755n 0.0v 9.745n 0.0v 9.755n 0.0v 14.745n 0.0v 14.755n 0.0v 19.745n 0.0v 19.755n 0.0v 24.745n 0.0v 24.755n 0.0v 29.745n 0.0v 29.755n 1.1v 34.745n 1.1v 34.755n 1.1v 39.745n 1.1v 39.755n 1.1v 44.745n 1.1v 44.755n 1.1v 49.745n 1.1v 49.755n 1.1v 54.745n 1.1v 54.755n 1.1v 59.745n 1.1v 59.755n 1.1v 64.745n 1.1v 64.755n 1.1v 69.745n 1.1v 69.755n 1.1v 74.745n 1.1v 74.755n 1.1v 79.745n 1.1v 79.755n 1.1v 84.745n 1.1v 84.755n 1.1v 89.745n 1.1v 89.755n 1.1v 94.745n 1.1v 94.755n 0.0v 99.745n 0.0v 99.755n 0.0v 104.745n 0.0v 104.755n 0.0v 109.745n 0.0v 109.755n 1.1v 114.745n 1.1v 114.755n 0.0v 119.745n 0.0v 119.755n 0.0v 124.745n 0.0v 124.755n 0.0v 129.745n 0.0v 129.755n 1.1v 134.745n 1.1v 134.755n 1.1v 139.745n 1.1v 139.755n 1.1v 144.745n 1.1v 144.755n 1.1v 149.745n 1.1v 149.755n 0.0v 154.745n 0.0v 154.755n 0.0v 159.745n 0.0v 159.755n 0.0v 164.745n 0.0v 164.755n 0.0v 169.745n 0.0v 169.755n 0.0v 174.745n 0.0v 174.755n 0.0v 179.745n 0.0v 179.755n 0.0v 184.745n 0.0v 184.755n 0.0v 189.745n 0.0v 189.755n 0.0v 194.745n 0.0v 194.755n 0.0v 199.745n 0.0v 199.755n 0.0v 204.745n 0.0v 204.755n 0.0v 209.745n 0.0v 209.755n 0.0v 214.745n 0.0v 214.755n 0.0v 219.745n 0.0v 219.755n 0.0v 224.745n 0.0v 224.755n 1.1v 229.745n 1.1v 229.755n 1.1v 234.745n 1.1v 234.755n 1.1v 239.745n 1.1v 239.755n 1.1v 244.745n 1.1v 244.755n 1.1v 249.745n 1.1v 249.755n 1.1v 254.745n 1.1v 254.755n 1.1v 259.745n 1.1v 259.755n 1.1v 264.745n 1.1v 264.755n 0.0v 269.745n 0.0v 269.755n 1.1v 274.745n 1.1v 274.755n 1.1v 279.745n 1.1v 279.755n 1.1v 284.745n 1.1v 284.755n 1.1v 289.745n 1.1v 289.755n 1.1v 294.745n 1.1v 294.755n 1.1v 299.745n 1.1v 299.755n 1.1v 304.745n 1.1v 304.755n 1.1v 309.745n 1.1v 309.755n 1.1v 314.745n 1.1v 314.755n 1.1v 319.745n 1.1v 319.755n 1.1v 324.745n 1.1v 324.755n 1.1v 329.745n 1.1v 329.755n 1.1v 334.745n 1.1v 334.755n 1.1v 339.745n 1.1v 339.755n 1.1v 344.745n 1.1v 344.755n 1.1v 349.745n 1.1v 349.755n 1.1v 354.745n 1.1v 354.755n 1.1v 359.745n 1.1v 359.755n 1.1v 364.745n 1.1v 364.755n 1.1v 369.745n 1.1v 369.755n 1.1v 374.745n 1.1v 374.755n 1.1v 379.745n 1.1v 379.755n 1.1v 384.745n 1.1v 384.755n 1.1v 389.745n 1.1v 389.755n 1.1v 394.745n 1.1v 394.755n 1.1v 399.745n 1.1v 399.755n 1.1v 404.745n 1.1v 404.755n 1.1v 409.745n 1.1v 409.755n 1.1v 414.745n 1.1v 414.755n 1.1v 419.745n 1.1v 419.755n 1.1v 424.745n 1.1v 424.755n 1.1v 429.745n 1.1v 429.755n 1.1v 434.745n 1.1v 434.755n 1.1v 439.745n 1.1v 439.755n 1.1v 444.745n 1.1v 444.755n 1.1v 449.745n 1.1v 449.755n 1.1v 454.745n 1.1v 454.755n 1.1v 459.745n 1.1v 459.755n 1.1v 464.745n 1.1v 464.755n 1.1v 469.745n 1.1v 469.755n 1.1v 474.745n 1.1v 474.755n 0.0v 479.745n 0.0v 479.755n 0.0v 484.745n 0.0v 484.755n 0.0v 489.745n 0.0v 489.755n 0.0v 494.745n 0.0v 494.755n 1.1v 499.745n 1.1v 499.755n 1.1v 504.745n 1.1v 504.755n 1.1v 509.745n 1.1v 509.755n 1.1v 514.745n 1.1v 514.755n 1.1v 519.745n 1.1v 519.755n 0.0v 524.745n 0.0v 524.755n 0.0v 529.745n 0.0v 529.755n 0.0v 534.745n 0.0v 534.755n 0.0v 539.745n 0.0v 539.755n 0.0v 544.745n 0.0v 544.755n 0.0v 549.745n 0.0v 549.755n 0.0v 554.745n 0.0v 554.755n 0.0v 559.745n 0.0v 559.755n 0.0v 564.745n 0.0v 564.755n 0.0v 569.745n 0.0v 569.755n 0.0v 574.745n 0.0v 574.755n 0.0v 579.745n 0.0v 579.755n 0.0v 584.745n 0.0v 584.755n 0.0v 589.745n 0.0v 589.755n 0.0v 594.745n 0.0v 594.755n 0.0v 599.745n 0.0v 599.755n 0.0v 604.745n 0.0v 604.755n 0.0v 609.745n 0.0v 609.755n 0.0v 614.745n 0.0v 614.755n 0.0v 619.745n 0.0v 619.755n 1.1v 624.745n 1.1v 624.755n 1.1v 629.745n 1.1v 629.755n 1.1v 634.745n 1.1v 634.755n 1.1v 639.745n 1.1v 639.755n 1.1v 644.745n 1.1v 644.755n 1.1v 649.745n 1.1v 649.755n 1.1v 654.745n 1.1v 654.755n 1.1v 659.745n 1.1v 659.755n 0.0v 664.745n 0.0v 664.755n 0.0v 669.745n 0.0v 669.755n 0.0v 674.745n 0.0v 674.755n 1.1v 679.745n 1.1v 679.755n 0.0v 684.745n 0.0v 684.755n 0.0v 689.745n 0.0v 689.755n 0.0v 694.745n 0.0v 694.755n 0.0v 699.745n 0.0v 699.755n 0.0v 704.745n 0.0v 704.755n 0.0v 709.745n 0.0v 709.755n 1.1v 714.745n 1.1v 714.755n 0.0v 719.745n 0.0v 719.755n 0.0v 724.745n 0.0v 724.755n 0.0v 729.745n 0.0v 729.755n 0.0v 734.745n 0.0v 734.755n 0.0v 739.745n 0.0v 739.755n 1.1v 744.745n 1.1v 744.755n 1.1v 749.745n 1.1v 749.755n 1.1v 754.745n 1.1v 754.755n 1.1v 759.745n 1.1v 759.755n 0.0v 764.745n 0.0v 764.755n 0.0v 769.745n 0.0v 769.755n 1.1v 774.745n 1.1v 774.755n 1.1v 779.745n 1.1v 779.755n 1.1v 784.745n 1.1v 784.755n 0.0v 789.745n 0.0v 789.755n 1.1v 794.745n 1.1v 794.755n 0.0v 799.745n 0.0v 799.755n 0.0v 804.745n 0.0v 804.755n 0.0v 809.745n 0.0v 809.755n 0.0v 814.745n 0.0v 814.755n 0.0v 819.745n 0.0v 819.755n 0.0v 824.745n 0.0v 824.755n 0.0v 829.745n 0.0v 829.755n 0.0v 834.745n 0.0v 834.755n 0.0v 839.745n 0.0v 839.755n 0.0v 844.745n 0.0v 844.755n 0.0v 849.745n 0.0v 849.755n 0.0v 854.745n 0.0v 854.755n 0.0v 859.745n 0.0v 859.755n 1.1v 864.745n 1.1v 864.755n 1.1v 869.745n 1.1v 869.755n 1.1v 874.745n 1.1v 874.755n 1.1v 879.745n 1.1v 879.755n 1.1v 884.745n 1.1v 884.755n 1.1v 889.745n 1.1v 889.755n 0.0v 894.745n 0.0v 894.755n 0.0v 899.745n 0.0v 899.755n 1.1v 904.745n 1.1v 904.755n 1.1v 909.745n 1.1v 909.755n 1.1v 914.745n 1.1v 914.755n 1.1v 919.745n 1.1v 919.755n 1.1v 924.745n 1.1v 924.755n 1.1v 929.745n 1.1v 929.755n 1.1v 934.745n 1.1v 934.755n 1.1v 939.745n 1.1v 939.755n 1.1v 944.745n 1.1v 944.755n 1.1v 949.745n 1.1v 949.755n 1.1v 954.745n 1.1v 954.755n 1.1v 959.745n 1.1v 959.755n 1.1v 964.745n 1.1v 964.755n 1.1v 969.745n 1.1v 969.755n 1.1v 974.745n 1.1v 974.755n 1.1v 979.745n 1.1v 979.755n 1.1v 984.745n 1.1v 984.755n 1.1v 989.745n 1.1v 989.755n 1.1v 994.745n 1.1v 994.755n 0.0v 999.745n 0.0v 999.755n 0.0v 1004.745n 0.0v 1004.755n 1.1v 1009.745n 1.1v 1009.755n 1.1v 1014.745n 1.1v 1014.755n 1.1v 1019.745n 1.1v 1019.755n 1.1v 1024.745n 1.1v 1024.755n 1.1v )
* (time, data): [(0, 0), (5, 1), (10, 1), (15, 1), (20, 1), (25, 1), (30, 0), (35, 1), (40, 1), (45, 1), (50, 1), (55, 1), (60, 0), (65, 1), (70, 1), (75, 1), (80, 0), (85, 0), (90, 0), (95, 0), (100, 0), (105, 0), (110, 0), (115, 1), (120, 1), (125, 1), (130, 1), (135, 1), (140, 1), (145, 1), (150, 0), (155, 1), (160, 1), (165, 1), (170, 1), (175, 1), (180, 1), (185, 1), (190, 1), (195, 1), (200, 1), (205, 1), (210, 1), (215, 1), (220, 1), (225, 0), (230, 0), (235, 0), (240, 0), (245, 0), (250, 0), (255, 0), (260, 0), (265, 1), (270, 0), (275, 0), (280, 0), (285, 0), (290, 0), (295, 0), (300, 0), (305, 0), (310, 0), (315, 0), (320, 0), (325, 0), (330, 0), (335, 0), (340, 0), (345, 0), (350, 0), (355, 0), (360, 0), (365, 0), (370, 0), (375, 0), (380, 0), (385, 0), (390, 0), (395, 0), (400, 0), (405, 0), (410, 0), (415, 0), (420, 0), (425, 0), (430, 0), (435, 0), (440, 0), (445, 0), (450, 0), (455, 0), (460, 0), (465, 0), (470, 0), (475, 1), (480, 1), (485, 1), (490, 1), (495, 1), (500, 1), (505, 1), (510, 1), (515, 1), (520, 1), (525, 0), (530, 0), (535, 1), (540, 1), (545, 1), (550, 1), (555, 1), (560, 1), (565, 1), (570, 1), (575, 1), (580, 1), (585, 1), (590, 1), (595, 1), (600, 1), (605, 1), (610, 1), (615, 1), (620, 0), (625, 0), (630, 0), (635, 0), (640, 0), (645, 1), (650, 1), (655, 1), (660, 0), (665, 0), (670, 0), (675, 0), (680, 0), (685, 0), (690, 0), (695, 0), (700, 0), (705, 0), (710, 1), (715, 1), (720, 1), (725, 1), (730, 1), (735, 1), (740, 1), (745, 1), (750, 1), (755, 1), (760, 1), (765, 1), (770, 1), (775, 1), (780, 1), (785, 1), (790, 1), (795, 0), (800, 0), (805, 0), (810, 0), (815, 0), (820, 0), (825, 0), (830, 0), (835, 0), (840, 0), (845, 0), (850, 0), (855, 0), (860, 1), (865, 1), (870, 1), (875, 0), (880, 0), (885, 0), (890, 1), (895, 1), (900, 0), (905, 0), (910, 0), (915, 0), (920, 0), (925, 0), (930, 0), (935, 0), (940, 0), (945, 0), (950, 0), (955, 0), (960, 0), (965, 0), (970, 0), (975, 0), (980, 0), (985, 0), (990, 0), (995, 1), (1000, 1), (1005, 0), (1010, 0), (1015, 0), (1020, 0), (1025, 0)]
Vdin0_9  din0_9  0 PWL (0n 0.0v 4.745n 0.0v 4.755n 1.1v 9.745n 1.1v 9.755n 1.1v 14.745n 1.1v 14.755n 1.1v 19.745n 1.1v 19.755n 1.1v 24.745n 1.1v 24.755n 1.1v 29.745n 1.1v 29.755n 0.0v 34.745n 0.0v 34.755n 1.1v 39.745n 1.1v 39.755n 1.1v 44.745n 1.1v 44.755n 1.1v 49.745n 1.1v 49.755n 1.1v 54.745n 1.1v 54.755n 1.1v 59.745n 1.1v 59.755n 0.0v 64.745n 0.0v 64.755n 1.1v 69.745n 1.1v 69.755n 1.1v 74.745n 1.1v 74.755n 1.1v 79.745n 1.1v 79.755n 0.0v 84.745n 0.0v 84.755n 0.0v 89.745n 0.0v 89.755n 0.0v 94.745n 0.0v 94.755n 0.0v 99.745n 0.0v 99.755n 0.0v 104.745n 0.0v 104.755n 0.0v 109.745n 0.0v 109.755n 0.0v 114.745n 0.0v 114.755n 1.1v 119.745n 1.1v 119.755n 1.1v 124.745n 1.1v 124.755n 1.1v 129.745n 1.1v 129.755n 1.1v 134.745n 1.1v 134.755n 1.1v 139.745n 1.1v 139.755n 1.1v 144.745n 1.1v 144.755n 1.1v 149.745n 1.1v 149.755n 0.0v 154.745n 0.0v 154.755n 1.1v 159.745n 1.1v 159.755n 1.1v 164.745n 1.1v 164.755n 1.1v 169.745n 1.1v 169.755n 1.1v 174.745n 1.1v 174.755n 1.1v 179.745n 1.1v 179.755n 1.1v 184.745n 1.1v 184.755n 1.1v 189.745n 1.1v 189.755n 1.1v 194.745n 1.1v 194.755n 1.1v 199.745n 1.1v 199.755n 1.1v 204.745n 1.1v 204.755n 1.1v 209.745n 1.1v 209.755n 1.1v 214.745n 1.1v 214.755n 1.1v 219.745n 1.1v 219.755n 1.1v 224.745n 1.1v 224.755n 0.0v 229.745n 0.0v 229.755n 0.0v 234.745n 0.0v 234.755n 0.0v 239.745n 0.0v 239.755n 0.0v 244.745n 0.0v 244.755n 0.0v 249.745n 0.0v 249.755n 0.0v 254.745n 0.0v 254.755n 0.0v 259.745n 0.0v 259.755n 0.0v 264.745n 0.0v 264.755n 1.1v 269.745n 1.1v 269.755n 0.0v 274.745n 0.0v 274.755n 0.0v 279.745n 0.0v 279.755n 0.0v 284.745n 0.0v 284.755n 0.0v 289.745n 0.0v 289.755n 0.0v 294.745n 0.0v 294.755n 0.0v 299.745n 0.0v 299.755n 0.0v 304.745n 0.0v 304.755n 0.0v 309.745n 0.0v 309.755n 0.0v 314.745n 0.0v 314.755n 0.0v 319.745n 0.0v 319.755n 0.0v 324.745n 0.0v 324.755n 0.0v 329.745n 0.0v 329.755n 0.0v 334.745n 0.0v 334.755n 0.0v 339.745n 0.0v 339.755n 0.0v 344.745n 0.0v 344.755n 0.0v 349.745n 0.0v 349.755n 0.0v 354.745n 0.0v 354.755n 0.0v 359.745n 0.0v 359.755n 0.0v 364.745n 0.0v 364.755n 0.0v 369.745n 0.0v 369.755n 0.0v 374.745n 0.0v 374.755n 0.0v 379.745n 0.0v 379.755n 0.0v 384.745n 0.0v 384.755n 0.0v 389.745n 0.0v 389.755n 0.0v 394.745n 0.0v 394.755n 0.0v 399.745n 0.0v 399.755n 0.0v 404.745n 0.0v 404.755n 0.0v 409.745n 0.0v 409.755n 0.0v 414.745n 0.0v 414.755n 0.0v 419.745n 0.0v 419.755n 0.0v 424.745n 0.0v 424.755n 0.0v 429.745n 0.0v 429.755n 0.0v 434.745n 0.0v 434.755n 0.0v 439.745n 0.0v 439.755n 0.0v 444.745n 0.0v 444.755n 0.0v 449.745n 0.0v 449.755n 0.0v 454.745n 0.0v 454.755n 0.0v 459.745n 0.0v 459.755n 0.0v 464.745n 0.0v 464.755n 0.0v 469.745n 0.0v 469.755n 0.0v 474.745n 0.0v 474.755n 1.1v 479.745n 1.1v 479.755n 1.1v 484.745n 1.1v 484.755n 1.1v 489.745n 1.1v 489.755n 1.1v 494.745n 1.1v 494.755n 1.1v 499.745n 1.1v 499.755n 1.1v 504.745n 1.1v 504.755n 1.1v 509.745n 1.1v 509.755n 1.1v 514.745n 1.1v 514.755n 1.1v 519.745n 1.1v 519.755n 1.1v 524.745n 1.1v 524.755n 0.0v 529.745n 0.0v 529.755n 0.0v 534.745n 0.0v 534.755n 1.1v 539.745n 1.1v 539.755n 1.1v 544.745n 1.1v 544.755n 1.1v 549.745n 1.1v 549.755n 1.1v 554.745n 1.1v 554.755n 1.1v 559.745n 1.1v 559.755n 1.1v 564.745n 1.1v 564.755n 1.1v 569.745n 1.1v 569.755n 1.1v 574.745n 1.1v 574.755n 1.1v 579.745n 1.1v 579.755n 1.1v 584.745n 1.1v 584.755n 1.1v 589.745n 1.1v 589.755n 1.1v 594.745n 1.1v 594.755n 1.1v 599.745n 1.1v 599.755n 1.1v 604.745n 1.1v 604.755n 1.1v 609.745n 1.1v 609.755n 1.1v 614.745n 1.1v 614.755n 1.1v 619.745n 1.1v 619.755n 0.0v 624.745n 0.0v 624.755n 0.0v 629.745n 0.0v 629.755n 0.0v 634.745n 0.0v 634.755n 0.0v 639.745n 0.0v 639.755n 0.0v 644.745n 0.0v 644.755n 1.1v 649.745n 1.1v 649.755n 1.1v 654.745n 1.1v 654.755n 1.1v 659.745n 1.1v 659.755n 0.0v 664.745n 0.0v 664.755n 0.0v 669.745n 0.0v 669.755n 0.0v 674.745n 0.0v 674.755n 0.0v 679.745n 0.0v 679.755n 0.0v 684.745n 0.0v 684.755n 0.0v 689.745n 0.0v 689.755n 0.0v 694.745n 0.0v 694.755n 0.0v 699.745n 0.0v 699.755n 0.0v 704.745n 0.0v 704.755n 0.0v 709.745n 0.0v 709.755n 1.1v 714.745n 1.1v 714.755n 1.1v 719.745n 1.1v 719.755n 1.1v 724.745n 1.1v 724.755n 1.1v 729.745n 1.1v 729.755n 1.1v 734.745n 1.1v 734.755n 1.1v 739.745n 1.1v 739.755n 1.1v 744.745n 1.1v 744.755n 1.1v 749.745n 1.1v 749.755n 1.1v 754.745n 1.1v 754.755n 1.1v 759.745n 1.1v 759.755n 1.1v 764.745n 1.1v 764.755n 1.1v 769.745n 1.1v 769.755n 1.1v 774.745n 1.1v 774.755n 1.1v 779.745n 1.1v 779.755n 1.1v 784.745n 1.1v 784.755n 1.1v 789.745n 1.1v 789.755n 1.1v 794.745n 1.1v 794.755n 0.0v 799.745n 0.0v 799.755n 0.0v 804.745n 0.0v 804.755n 0.0v 809.745n 0.0v 809.755n 0.0v 814.745n 0.0v 814.755n 0.0v 819.745n 0.0v 819.755n 0.0v 824.745n 0.0v 824.755n 0.0v 829.745n 0.0v 829.755n 0.0v 834.745n 0.0v 834.755n 0.0v 839.745n 0.0v 839.755n 0.0v 844.745n 0.0v 844.755n 0.0v 849.745n 0.0v 849.755n 0.0v 854.745n 0.0v 854.755n 0.0v 859.745n 0.0v 859.755n 1.1v 864.745n 1.1v 864.755n 1.1v 869.745n 1.1v 869.755n 1.1v 874.745n 1.1v 874.755n 0.0v 879.745n 0.0v 879.755n 0.0v 884.745n 0.0v 884.755n 0.0v 889.745n 0.0v 889.755n 1.1v 894.745n 1.1v 894.755n 1.1v 899.745n 1.1v 899.755n 0.0v 904.745n 0.0v 904.755n 0.0v 909.745n 0.0v 909.755n 0.0v 914.745n 0.0v 914.755n 0.0v 919.745n 0.0v 919.755n 0.0v 924.745n 0.0v 924.755n 0.0v 929.745n 0.0v 929.755n 0.0v 934.745n 0.0v 934.755n 0.0v 939.745n 0.0v 939.755n 0.0v 944.745n 0.0v 944.755n 0.0v 949.745n 0.0v 949.755n 0.0v 954.745n 0.0v 954.755n 0.0v 959.745n 0.0v 959.755n 0.0v 964.745n 0.0v 964.755n 0.0v 969.745n 0.0v 969.755n 0.0v 974.745n 0.0v 974.755n 0.0v 979.745n 0.0v 979.755n 0.0v 984.745n 0.0v 984.755n 0.0v 989.745n 0.0v 989.755n 0.0v 994.745n 0.0v 994.755n 1.1v 999.745n 1.1v 999.755n 1.1v 1004.745n 1.1v 1004.755n 0.0v 1009.745n 0.0v 1009.755n 0.0v 1014.745n 0.0v 1014.755n 0.0v 1019.745n 0.0v 1019.755n 0.0v 1024.745n 0.0v 1024.755n 0.0v )
* (time, data): [(0, 0), (5, 0), (10, 1), (15, 1), (20, 1), (25, 1), (30, 0), (35, 0), (40, 0), (45, 0), (50, 0), (55, 0), (60, 0), (65, 0), (70, 0), (75, 0), (80, 0), (85, 0), (90, 0), (95, 0), (100, 0), (105, 0), (110, 1), (115, 0), (120, 0), (125, 0), (130, 1), (135, 0), (140, 0), (145, 0), (150, 1), (155, 0), (160, 0), (165, 0), (170, 0), (175, 0), (180, 0), (185, 0), (190, 0), (195, 0), (200, 0), (205, 0), (210, 0), (215, 0), (220, 0), (225, 0), (230, 0), (235, 0), (240, 0), (245, 0), (250, 0), (255, 0), (260, 0), (265, 0), (270, 1), (275, 1), (280, 1), (285, 1), (290, 1), (295, 1), (300, 1), (305, 1), (310, 1), (315, 1), (320, 1), (325, 1), (330, 1), (335, 1), (340, 1), (345, 1), (350, 1), (355, 0), (360, 0), (365, 0), (370, 0), (375, 0), (380, 1), (385, 1), (390, 1), (395, 1), (400, 1), (405, 1), (410, 1), (415, 1), (420, 0), (425, 0), (430, 0), (435, 0), (440, 0), (445, 0), (450, 0), (455, 0), (460, 0), (465, 0), (470, 1), (475, 1), (480, 1), (485, 1), (490, 1), (495, 0), (500, 0), (505, 0), (510, 0), (515, 0), (520, 1), (525, 1), (530, 1), (535, 0), (540, 0), (545, 0), (550, 0), (555, 0), (560, 0), (565, 0), (570, 0), (575, 0), (580, 0), (585, 0), (590, 0), (595, 0), (600, 0), (605, 0), (610, 0), (615, 0), (620, 0), (625, 0), (630, 0), (635, 0), (640, 0), (645, 0), (650, 0), (655, 0), (660, 0), (665, 1), (670, 1), (675, 0), (680, 0), (685, 0), (690, 0), (695, 0), (700, 0), (705, 0), (710, 1), (715, 1), (720, 1), (725, 1), (730, 1), (735, 1), (740, 0), (745, 0), (750, 0), (755, 0), (760, 1), (765, 1), (770, 0), (775, 0), (780, 0), (785, 1), (790, 1), (795, 0), (800, 0), (805, 0), (810, 0), (815, 0), (820, 0), (825, 0), (830, 0), (835, 0), (840, 0), (845, 0), (850, 0), (855, 0), (860, 1), (865, 0), (870, 0), (875, 0), (880, 0), (885, 0), (890, 1), (895, 1), (900, 1), (905, 1), (910, 1), (915, 1), (920, 1), (925, 1), (930, 1), (935, 1), (940, 1), (945, 1), (950, 1), (955, 1), (960, 1), (965, 1), (970, 1), (975, 0), (980, 0), (985, 0), (990, 0), (995, 0), (1000, 0), (1005, 1), (1010, 1), (1015, 1), (1020, 1), (1025, 1)]
Vdin0_10  din0_10  0 PWL (0n 0.0v 4.745n 0.0v 4.755n 0.0v 9.745n 0.0v 9.755n 1.1v 14.745n 1.1v 14.755n 1.1v 19.745n 1.1v 19.755n 1.1v 24.745n 1.1v 24.755n 1.1v 29.745n 1.1v 29.755n 0.0v 34.745n 0.0v 34.755n 0.0v 39.745n 0.0v 39.755n 0.0v 44.745n 0.0v 44.755n 0.0v 49.745n 0.0v 49.755n 0.0v 54.745n 0.0v 54.755n 0.0v 59.745n 0.0v 59.755n 0.0v 64.745n 0.0v 64.755n 0.0v 69.745n 0.0v 69.755n 0.0v 74.745n 0.0v 74.755n 0.0v 79.745n 0.0v 79.755n 0.0v 84.745n 0.0v 84.755n 0.0v 89.745n 0.0v 89.755n 0.0v 94.745n 0.0v 94.755n 0.0v 99.745n 0.0v 99.755n 0.0v 104.745n 0.0v 104.755n 0.0v 109.745n 0.0v 109.755n 1.1v 114.745n 1.1v 114.755n 0.0v 119.745n 0.0v 119.755n 0.0v 124.745n 0.0v 124.755n 0.0v 129.745n 0.0v 129.755n 1.1v 134.745n 1.1v 134.755n 0.0v 139.745n 0.0v 139.755n 0.0v 144.745n 0.0v 144.755n 0.0v 149.745n 0.0v 149.755n 1.1v 154.745n 1.1v 154.755n 0.0v 159.745n 0.0v 159.755n 0.0v 164.745n 0.0v 164.755n 0.0v 169.745n 0.0v 169.755n 0.0v 174.745n 0.0v 174.755n 0.0v 179.745n 0.0v 179.755n 0.0v 184.745n 0.0v 184.755n 0.0v 189.745n 0.0v 189.755n 0.0v 194.745n 0.0v 194.755n 0.0v 199.745n 0.0v 199.755n 0.0v 204.745n 0.0v 204.755n 0.0v 209.745n 0.0v 209.755n 0.0v 214.745n 0.0v 214.755n 0.0v 219.745n 0.0v 219.755n 0.0v 224.745n 0.0v 224.755n 0.0v 229.745n 0.0v 229.755n 0.0v 234.745n 0.0v 234.755n 0.0v 239.745n 0.0v 239.755n 0.0v 244.745n 0.0v 244.755n 0.0v 249.745n 0.0v 249.755n 0.0v 254.745n 0.0v 254.755n 0.0v 259.745n 0.0v 259.755n 0.0v 264.745n 0.0v 264.755n 0.0v 269.745n 0.0v 269.755n 1.1v 274.745n 1.1v 274.755n 1.1v 279.745n 1.1v 279.755n 1.1v 284.745n 1.1v 284.755n 1.1v 289.745n 1.1v 289.755n 1.1v 294.745n 1.1v 294.755n 1.1v 299.745n 1.1v 299.755n 1.1v 304.745n 1.1v 304.755n 1.1v 309.745n 1.1v 309.755n 1.1v 314.745n 1.1v 314.755n 1.1v 319.745n 1.1v 319.755n 1.1v 324.745n 1.1v 324.755n 1.1v 329.745n 1.1v 329.755n 1.1v 334.745n 1.1v 334.755n 1.1v 339.745n 1.1v 339.755n 1.1v 344.745n 1.1v 344.755n 1.1v 349.745n 1.1v 349.755n 1.1v 354.745n 1.1v 354.755n 0.0v 359.745n 0.0v 359.755n 0.0v 364.745n 0.0v 364.755n 0.0v 369.745n 0.0v 369.755n 0.0v 374.745n 0.0v 374.755n 0.0v 379.745n 0.0v 379.755n 1.1v 384.745n 1.1v 384.755n 1.1v 389.745n 1.1v 389.755n 1.1v 394.745n 1.1v 394.755n 1.1v 399.745n 1.1v 399.755n 1.1v 404.745n 1.1v 404.755n 1.1v 409.745n 1.1v 409.755n 1.1v 414.745n 1.1v 414.755n 1.1v 419.745n 1.1v 419.755n 0.0v 424.745n 0.0v 424.755n 0.0v 429.745n 0.0v 429.755n 0.0v 434.745n 0.0v 434.755n 0.0v 439.745n 0.0v 439.755n 0.0v 444.745n 0.0v 444.755n 0.0v 449.745n 0.0v 449.755n 0.0v 454.745n 0.0v 454.755n 0.0v 459.745n 0.0v 459.755n 0.0v 464.745n 0.0v 464.755n 0.0v 469.745n 0.0v 469.755n 1.1v 474.745n 1.1v 474.755n 1.1v 479.745n 1.1v 479.755n 1.1v 484.745n 1.1v 484.755n 1.1v 489.745n 1.1v 489.755n 1.1v 494.745n 1.1v 494.755n 0.0v 499.745n 0.0v 499.755n 0.0v 504.745n 0.0v 504.755n 0.0v 509.745n 0.0v 509.755n 0.0v 514.745n 0.0v 514.755n 0.0v 519.745n 0.0v 519.755n 1.1v 524.745n 1.1v 524.755n 1.1v 529.745n 1.1v 529.755n 1.1v 534.745n 1.1v 534.755n 0.0v 539.745n 0.0v 539.755n 0.0v 544.745n 0.0v 544.755n 0.0v 549.745n 0.0v 549.755n 0.0v 554.745n 0.0v 554.755n 0.0v 559.745n 0.0v 559.755n 0.0v 564.745n 0.0v 564.755n 0.0v 569.745n 0.0v 569.755n 0.0v 574.745n 0.0v 574.755n 0.0v 579.745n 0.0v 579.755n 0.0v 584.745n 0.0v 584.755n 0.0v 589.745n 0.0v 589.755n 0.0v 594.745n 0.0v 594.755n 0.0v 599.745n 0.0v 599.755n 0.0v 604.745n 0.0v 604.755n 0.0v 609.745n 0.0v 609.755n 0.0v 614.745n 0.0v 614.755n 0.0v 619.745n 0.0v 619.755n 0.0v 624.745n 0.0v 624.755n 0.0v 629.745n 0.0v 629.755n 0.0v 634.745n 0.0v 634.755n 0.0v 639.745n 0.0v 639.755n 0.0v 644.745n 0.0v 644.755n 0.0v 649.745n 0.0v 649.755n 0.0v 654.745n 0.0v 654.755n 0.0v 659.745n 0.0v 659.755n 0.0v 664.745n 0.0v 664.755n 1.1v 669.745n 1.1v 669.755n 1.1v 674.745n 1.1v 674.755n 0.0v 679.745n 0.0v 679.755n 0.0v 684.745n 0.0v 684.755n 0.0v 689.745n 0.0v 689.755n 0.0v 694.745n 0.0v 694.755n 0.0v 699.745n 0.0v 699.755n 0.0v 704.745n 0.0v 704.755n 0.0v 709.745n 0.0v 709.755n 1.1v 714.745n 1.1v 714.755n 1.1v 719.745n 1.1v 719.755n 1.1v 724.745n 1.1v 724.755n 1.1v 729.745n 1.1v 729.755n 1.1v 734.745n 1.1v 734.755n 1.1v 739.745n 1.1v 739.755n 0.0v 744.745n 0.0v 744.755n 0.0v 749.745n 0.0v 749.755n 0.0v 754.745n 0.0v 754.755n 0.0v 759.745n 0.0v 759.755n 1.1v 764.745n 1.1v 764.755n 1.1v 769.745n 1.1v 769.755n 0.0v 774.745n 0.0v 774.755n 0.0v 779.745n 0.0v 779.755n 0.0v 784.745n 0.0v 784.755n 1.1v 789.745n 1.1v 789.755n 1.1v 794.745n 1.1v 794.755n 0.0v 799.745n 0.0v 799.755n 0.0v 804.745n 0.0v 804.755n 0.0v 809.745n 0.0v 809.755n 0.0v 814.745n 0.0v 814.755n 0.0v 819.745n 0.0v 819.755n 0.0v 824.745n 0.0v 824.755n 0.0v 829.745n 0.0v 829.755n 0.0v 834.745n 0.0v 834.755n 0.0v 839.745n 0.0v 839.755n 0.0v 844.745n 0.0v 844.755n 0.0v 849.745n 0.0v 849.755n 0.0v 854.745n 0.0v 854.755n 0.0v 859.745n 0.0v 859.755n 1.1v 864.745n 1.1v 864.755n 0.0v 869.745n 0.0v 869.755n 0.0v 874.745n 0.0v 874.755n 0.0v 879.745n 0.0v 879.755n 0.0v 884.745n 0.0v 884.755n 0.0v 889.745n 0.0v 889.755n 1.1v 894.745n 1.1v 894.755n 1.1v 899.745n 1.1v 899.755n 1.1v 904.745n 1.1v 904.755n 1.1v 909.745n 1.1v 909.755n 1.1v 914.745n 1.1v 914.755n 1.1v 919.745n 1.1v 919.755n 1.1v 924.745n 1.1v 924.755n 1.1v 929.745n 1.1v 929.755n 1.1v 934.745n 1.1v 934.755n 1.1v 939.745n 1.1v 939.755n 1.1v 944.745n 1.1v 944.755n 1.1v 949.745n 1.1v 949.755n 1.1v 954.745n 1.1v 954.755n 1.1v 959.745n 1.1v 959.755n 1.1v 964.745n 1.1v 964.755n 1.1v 969.745n 1.1v 969.755n 1.1v 974.745n 1.1v 974.755n 0.0v 979.745n 0.0v 979.755n 0.0v 984.745n 0.0v 984.755n 0.0v 989.745n 0.0v 989.755n 0.0v 994.745n 0.0v 994.755n 0.0v 999.745n 0.0v 999.755n 0.0v 1004.745n 0.0v 1004.755n 1.1v 1009.745n 1.1v 1009.755n 1.1v 1014.745n 1.1v 1014.755n 1.1v 1019.745n 1.1v 1019.755n 1.1v 1024.745n 1.1v 1024.755n 1.1v )
* (time, data): [(0, 0), (5, 1), (10, 1), (15, 1), (20, 1), (25, 1), (30, 0), (35, 1), (40, 1), (45, 1), (50, 1), (55, 1), (60, 1), (65, 0), (70, 0), (75, 0), (80, 1), (85, 1), (90, 1), (95, 0), (100, 0), (105, 0), (110, 1), (115, 1), (120, 1), (125, 1), (130, 1), (135, 1), (140, 0), (145, 0), (150, 0), (155, 1), (160, 1), (165, 1), (170, 1), (175, 1), (180, 1), (185, 1), (190, 1), (195, 1), (200, 1), (205, 1), (210, 1), (215, 1), (220, 1), (225, 1), (230, 1), (235, 1), (240, 1), (245, 1), (250, 1), (255, 1), (260, 1), (265, 1), (270, 1), (275, 1), (280, 1), (285, 1), (290, 1), (295, 1), (300, 1), (305, 1), (310, 1), (315, 1), (320, 1), (325, 1), (330, 1), (335, 1), (340, 1), (345, 1), (350, 1), (355, 1), (360, 1), (365, 1), (370, 1), (375, 1), (380, 0), (385, 0), (390, 0), (395, 0), (400, 0), (405, 0), (410, 0), (415, 0), (420, 0), (425, 0), (430, 0), (435, 0), (440, 0), (445, 0), (450, 0), (455, 0), (460, 0), (465, 0), (470, 1), (475, 0), (480, 0), (485, 0), (490, 0), (495, 0), (500, 0), (505, 0), (510, 0), (515, 0), (520, 0), (525, 1), (530, 1), (535, 0), (540, 0), (545, 0), (550, 0), (555, 0), (560, 0), (565, 0), (570, 0), (575, 0), (580, 0), (585, 0), (590, 0), (595, 0), (600, 0), (605, 0), (610, 0), (615, 0), (620, 0), (625, 0), (630, 0), (635, 0), (640, 0), (645, 0), (650, 0), (655, 0), (660, 1), (665, 0), (670, 0), (675, 0), (680, 1), (685, 1), (690, 1), (695, 1), (700, 1), (705, 1), (710, 1), (715, 0), (720, 0), (725, 0), (730, 0), (735, 0), (740, 1), (745, 1), (750, 1), (755, 1), (760, 1), (765, 1), (770, 0), (775, 0), (780, 0), (785, 0), (790, 0), (795, 1), (800, 1), (805, 1), (810, 1), (815, 1), (820, 1), (825, 1), (830, 1), (835, 1), (840, 1), (845, 0), (850, 0), (855, 0), (860, 1), (865, 0), (870, 0), (875, 0), (880, 0), (885, 0), (890, 0), (895, 0), (900, 1), (905, 1), (910, 0), (915, 0), (920, 0), (925, 0), (930, 0), (935, 0), (940, 0), (945, 0), (950, 0), (955, 0), (960, 0), (965, 0), (970, 0), (975, 1), (980, 1), (985, 1), (990, 1), (995, 0), (1000, 0), (1005, 0), (1010, 0), (1015, 0), (1020, 0), (1025, 0)]
Vdin0_11  din0_11  0 PWL (0n 0.0v 4.745n 0.0v 4.755n 1.1v 9.745n 1.1v 9.755n 1.1v 14.745n 1.1v 14.755n 1.1v 19.745n 1.1v 19.755n 1.1v 24.745n 1.1v 24.755n 1.1v 29.745n 1.1v 29.755n 0.0v 34.745n 0.0v 34.755n 1.1v 39.745n 1.1v 39.755n 1.1v 44.745n 1.1v 44.755n 1.1v 49.745n 1.1v 49.755n 1.1v 54.745n 1.1v 54.755n 1.1v 59.745n 1.1v 59.755n 1.1v 64.745n 1.1v 64.755n 0.0v 69.745n 0.0v 69.755n 0.0v 74.745n 0.0v 74.755n 0.0v 79.745n 0.0v 79.755n 1.1v 84.745n 1.1v 84.755n 1.1v 89.745n 1.1v 89.755n 1.1v 94.745n 1.1v 94.755n 0.0v 99.745n 0.0v 99.755n 0.0v 104.745n 0.0v 104.755n 0.0v 109.745n 0.0v 109.755n 1.1v 114.745n 1.1v 114.755n 1.1v 119.745n 1.1v 119.755n 1.1v 124.745n 1.1v 124.755n 1.1v 129.745n 1.1v 129.755n 1.1v 134.745n 1.1v 134.755n 1.1v 139.745n 1.1v 139.755n 0.0v 144.745n 0.0v 144.755n 0.0v 149.745n 0.0v 149.755n 0.0v 154.745n 0.0v 154.755n 1.1v 159.745n 1.1v 159.755n 1.1v 164.745n 1.1v 164.755n 1.1v 169.745n 1.1v 169.755n 1.1v 174.745n 1.1v 174.755n 1.1v 179.745n 1.1v 179.755n 1.1v 184.745n 1.1v 184.755n 1.1v 189.745n 1.1v 189.755n 1.1v 194.745n 1.1v 194.755n 1.1v 199.745n 1.1v 199.755n 1.1v 204.745n 1.1v 204.755n 1.1v 209.745n 1.1v 209.755n 1.1v 214.745n 1.1v 214.755n 1.1v 219.745n 1.1v 219.755n 1.1v 224.745n 1.1v 224.755n 1.1v 229.745n 1.1v 229.755n 1.1v 234.745n 1.1v 234.755n 1.1v 239.745n 1.1v 239.755n 1.1v 244.745n 1.1v 244.755n 1.1v 249.745n 1.1v 249.755n 1.1v 254.745n 1.1v 254.755n 1.1v 259.745n 1.1v 259.755n 1.1v 264.745n 1.1v 264.755n 1.1v 269.745n 1.1v 269.755n 1.1v 274.745n 1.1v 274.755n 1.1v 279.745n 1.1v 279.755n 1.1v 284.745n 1.1v 284.755n 1.1v 289.745n 1.1v 289.755n 1.1v 294.745n 1.1v 294.755n 1.1v 299.745n 1.1v 299.755n 1.1v 304.745n 1.1v 304.755n 1.1v 309.745n 1.1v 309.755n 1.1v 314.745n 1.1v 314.755n 1.1v 319.745n 1.1v 319.755n 1.1v 324.745n 1.1v 324.755n 1.1v 329.745n 1.1v 329.755n 1.1v 334.745n 1.1v 334.755n 1.1v 339.745n 1.1v 339.755n 1.1v 344.745n 1.1v 344.755n 1.1v 349.745n 1.1v 349.755n 1.1v 354.745n 1.1v 354.755n 1.1v 359.745n 1.1v 359.755n 1.1v 364.745n 1.1v 364.755n 1.1v 369.745n 1.1v 369.755n 1.1v 374.745n 1.1v 374.755n 1.1v 379.745n 1.1v 379.755n 0.0v 384.745n 0.0v 384.755n 0.0v 389.745n 0.0v 389.755n 0.0v 394.745n 0.0v 394.755n 0.0v 399.745n 0.0v 399.755n 0.0v 404.745n 0.0v 404.755n 0.0v 409.745n 0.0v 409.755n 0.0v 414.745n 0.0v 414.755n 0.0v 419.745n 0.0v 419.755n 0.0v 424.745n 0.0v 424.755n 0.0v 429.745n 0.0v 429.755n 0.0v 434.745n 0.0v 434.755n 0.0v 439.745n 0.0v 439.755n 0.0v 444.745n 0.0v 444.755n 0.0v 449.745n 0.0v 449.755n 0.0v 454.745n 0.0v 454.755n 0.0v 459.745n 0.0v 459.755n 0.0v 464.745n 0.0v 464.755n 0.0v 469.745n 0.0v 469.755n 1.1v 474.745n 1.1v 474.755n 0.0v 479.745n 0.0v 479.755n 0.0v 484.745n 0.0v 484.755n 0.0v 489.745n 0.0v 489.755n 0.0v 494.745n 0.0v 494.755n 0.0v 499.745n 0.0v 499.755n 0.0v 504.745n 0.0v 504.755n 0.0v 509.745n 0.0v 509.755n 0.0v 514.745n 0.0v 514.755n 0.0v 519.745n 0.0v 519.755n 0.0v 524.745n 0.0v 524.755n 1.1v 529.745n 1.1v 529.755n 1.1v 534.745n 1.1v 534.755n 0.0v 539.745n 0.0v 539.755n 0.0v 544.745n 0.0v 544.755n 0.0v 549.745n 0.0v 549.755n 0.0v 554.745n 0.0v 554.755n 0.0v 559.745n 0.0v 559.755n 0.0v 564.745n 0.0v 564.755n 0.0v 569.745n 0.0v 569.755n 0.0v 574.745n 0.0v 574.755n 0.0v 579.745n 0.0v 579.755n 0.0v 584.745n 0.0v 584.755n 0.0v 589.745n 0.0v 589.755n 0.0v 594.745n 0.0v 594.755n 0.0v 599.745n 0.0v 599.755n 0.0v 604.745n 0.0v 604.755n 0.0v 609.745n 0.0v 609.755n 0.0v 614.745n 0.0v 614.755n 0.0v 619.745n 0.0v 619.755n 0.0v 624.745n 0.0v 624.755n 0.0v 629.745n 0.0v 629.755n 0.0v 634.745n 0.0v 634.755n 0.0v 639.745n 0.0v 639.755n 0.0v 644.745n 0.0v 644.755n 0.0v 649.745n 0.0v 649.755n 0.0v 654.745n 0.0v 654.755n 0.0v 659.745n 0.0v 659.755n 1.1v 664.745n 1.1v 664.755n 0.0v 669.745n 0.0v 669.755n 0.0v 674.745n 0.0v 674.755n 0.0v 679.745n 0.0v 679.755n 1.1v 684.745n 1.1v 684.755n 1.1v 689.745n 1.1v 689.755n 1.1v 694.745n 1.1v 694.755n 1.1v 699.745n 1.1v 699.755n 1.1v 704.745n 1.1v 704.755n 1.1v 709.745n 1.1v 709.755n 1.1v 714.745n 1.1v 714.755n 0.0v 719.745n 0.0v 719.755n 0.0v 724.745n 0.0v 724.755n 0.0v 729.745n 0.0v 729.755n 0.0v 734.745n 0.0v 734.755n 0.0v 739.745n 0.0v 739.755n 1.1v 744.745n 1.1v 744.755n 1.1v 749.745n 1.1v 749.755n 1.1v 754.745n 1.1v 754.755n 1.1v 759.745n 1.1v 759.755n 1.1v 764.745n 1.1v 764.755n 1.1v 769.745n 1.1v 769.755n 0.0v 774.745n 0.0v 774.755n 0.0v 779.745n 0.0v 779.755n 0.0v 784.745n 0.0v 784.755n 0.0v 789.745n 0.0v 789.755n 0.0v 794.745n 0.0v 794.755n 1.1v 799.745n 1.1v 799.755n 1.1v 804.745n 1.1v 804.755n 1.1v 809.745n 1.1v 809.755n 1.1v 814.745n 1.1v 814.755n 1.1v 819.745n 1.1v 819.755n 1.1v 824.745n 1.1v 824.755n 1.1v 829.745n 1.1v 829.755n 1.1v 834.745n 1.1v 834.755n 1.1v 839.745n 1.1v 839.755n 1.1v 844.745n 1.1v 844.755n 0.0v 849.745n 0.0v 849.755n 0.0v 854.745n 0.0v 854.755n 0.0v 859.745n 0.0v 859.755n 1.1v 864.745n 1.1v 864.755n 0.0v 869.745n 0.0v 869.755n 0.0v 874.745n 0.0v 874.755n 0.0v 879.745n 0.0v 879.755n 0.0v 884.745n 0.0v 884.755n 0.0v 889.745n 0.0v 889.755n 0.0v 894.745n 0.0v 894.755n 0.0v 899.745n 0.0v 899.755n 1.1v 904.745n 1.1v 904.755n 1.1v 909.745n 1.1v 909.755n 0.0v 914.745n 0.0v 914.755n 0.0v 919.745n 0.0v 919.755n 0.0v 924.745n 0.0v 924.755n 0.0v 929.745n 0.0v 929.755n 0.0v 934.745n 0.0v 934.755n 0.0v 939.745n 0.0v 939.755n 0.0v 944.745n 0.0v 944.755n 0.0v 949.745n 0.0v 949.755n 0.0v 954.745n 0.0v 954.755n 0.0v 959.745n 0.0v 959.755n 0.0v 964.745n 0.0v 964.755n 0.0v 969.745n 0.0v 969.755n 0.0v 974.745n 0.0v 974.755n 1.1v 979.745n 1.1v 979.755n 1.1v 984.745n 1.1v 984.755n 1.1v 989.745n 1.1v 989.755n 1.1v 994.745n 1.1v 994.755n 0.0v 999.745n 0.0v 999.755n 0.0v 1004.745n 0.0v 1004.755n 0.0v 1009.745n 0.0v 1009.755n 0.0v 1014.745n 0.0v 1014.755n 0.0v 1019.745n 0.0v 1019.755n 0.0v 1024.745n 0.0v 1024.755n 0.0v )
* (time, data): [(0, 0), (5, 0), (10, 0), (15, 0), (20, 0), (25, 0), (30, 1), (35, 0), (40, 0), (45, 0), (50, 0), (55, 0), (60, 1), (65, 0), (70, 0), (75, 0), (80, 0), (85, 0), (90, 0), (95, 1), (100, 1), (105, 1), (110, 0), (115, 0), (120, 0), (125, 0), (130, 0), (135, 0), (140, 1), (145, 1), (150, 0), (155, 1), (160, 1), (165, 1), (170, 1), (175, 1), (180, 1), (185, 1), (190, 1), (195, 1), (200, 1), (205, 1), (210, 1), (215, 1), (220, 1), (225, 1), (230, 1), (235, 1), (240, 1), (245, 1), (250, 1), (255, 1), (260, 1), (265, 1), (270, 0), (275, 0), (280, 0), (285, 0), (290, 0), (295, 0), (300, 0), (305, 0), (310, 0), (315, 0), (320, 0), (325, 0), (330, 0), (335, 0), (340, 0), (345, 0), (350, 0), (355, 1), (360, 1), (365, 1), (370, 1), (375, 1), (380, 0), (385, 0), (390, 0), (395, 0), (400, 0), (405, 0), (410, 0), (415, 0), (420, 0), (425, 0), (430, 0), (435, 0), (440, 0), (445, 0), (450, 0), (455, 0), (460, 0), (465, 0), (470, 0), (475, 0), (480, 0), (485, 0), (490, 0), (495, 1), (500, 1), (505, 1), (510, 1), (515, 1), (520, 0), (525, 0), (530, 0), (535, 1), (540, 1), (545, 1), (550, 1), (555, 1), (560, 1), (565, 1), (570, 1), (575, 1), (580, 1), (585, 1), (590, 1), (595, 1), (600, 1), (605, 1), (610, 1), (615, 1), (620, 0), (625, 0), (630, 0), (635, 0), (640, 0), (645, 1), (650, 1), (655, 1), (660, 0), (665, 1), (670, 1), (675, 1), (680, 0), (685, 0), (690, 0), (695, 0), (700, 0), (705, 0), (710, 1), (715, 0), (720, 0), (725, 0), (730, 0), (735, 0), (740, 1), (745, 1), (750, 1), (755, 1), (760, 0), (765, 0), (770, 1), (775, 1), (780, 1), (785, 1), (790, 0), (795, 1), (800, 1), (805, 1), (810, 1), (815, 1), (820, 1), (825, 1), (830, 1), (835, 1), (840, 1), (845, 1), (850, 1), (855, 1), (860, 1), (865, 1), (870, 1), (875, 0), (880, 0), (885, 0), (890, 1), (895, 1), (900, 1), (905, 1), (910, 0), (915, 0), (920, 0), (925, 0), (930, 0), (935, 0), (940, 0), (945, 0), (950, 0), (955, 0), (960, 0), (965, 0), (970, 0), (975, 0), (980, 0), (985, 0), (990, 0), (995, 0), (1000, 0), (1005, 0), (1010, 0), (1015, 0), (1020, 0), (1025, 0)]
Vdin0_12  din0_12  0 PWL (0n 0.0v 4.745n 0.0v 4.755n 0.0v 9.745n 0.0v 9.755n 0.0v 14.745n 0.0v 14.755n 0.0v 19.745n 0.0v 19.755n 0.0v 24.745n 0.0v 24.755n 0.0v 29.745n 0.0v 29.755n 1.1v 34.745n 1.1v 34.755n 0.0v 39.745n 0.0v 39.755n 0.0v 44.745n 0.0v 44.755n 0.0v 49.745n 0.0v 49.755n 0.0v 54.745n 0.0v 54.755n 0.0v 59.745n 0.0v 59.755n 1.1v 64.745n 1.1v 64.755n 0.0v 69.745n 0.0v 69.755n 0.0v 74.745n 0.0v 74.755n 0.0v 79.745n 0.0v 79.755n 0.0v 84.745n 0.0v 84.755n 0.0v 89.745n 0.0v 89.755n 0.0v 94.745n 0.0v 94.755n 1.1v 99.745n 1.1v 99.755n 1.1v 104.745n 1.1v 104.755n 1.1v 109.745n 1.1v 109.755n 0.0v 114.745n 0.0v 114.755n 0.0v 119.745n 0.0v 119.755n 0.0v 124.745n 0.0v 124.755n 0.0v 129.745n 0.0v 129.755n 0.0v 134.745n 0.0v 134.755n 0.0v 139.745n 0.0v 139.755n 1.1v 144.745n 1.1v 144.755n 1.1v 149.745n 1.1v 149.755n 0.0v 154.745n 0.0v 154.755n 1.1v 159.745n 1.1v 159.755n 1.1v 164.745n 1.1v 164.755n 1.1v 169.745n 1.1v 169.755n 1.1v 174.745n 1.1v 174.755n 1.1v 179.745n 1.1v 179.755n 1.1v 184.745n 1.1v 184.755n 1.1v 189.745n 1.1v 189.755n 1.1v 194.745n 1.1v 194.755n 1.1v 199.745n 1.1v 199.755n 1.1v 204.745n 1.1v 204.755n 1.1v 209.745n 1.1v 209.755n 1.1v 214.745n 1.1v 214.755n 1.1v 219.745n 1.1v 219.755n 1.1v 224.745n 1.1v 224.755n 1.1v 229.745n 1.1v 229.755n 1.1v 234.745n 1.1v 234.755n 1.1v 239.745n 1.1v 239.755n 1.1v 244.745n 1.1v 244.755n 1.1v 249.745n 1.1v 249.755n 1.1v 254.745n 1.1v 254.755n 1.1v 259.745n 1.1v 259.755n 1.1v 264.745n 1.1v 264.755n 1.1v 269.745n 1.1v 269.755n 0.0v 274.745n 0.0v 274.755n 0.0v 279.745n 0.0v 279.755n 0.0v 284.745n 0.0v 284.755n 0.0v 289.745n 0.0v 289.755n 0.0v 294.745n 0.0v 294.755n 0.0v 299.745n 0.0v 299.755n 0.0v 304.745n 0.0v 304.755n 0.0v 309.745n 0.0v 309.755n 0.0v 314.745n 0.0v 314.755n 0.0v 319.745n 0.0v 319.755n 0.0v 324.745n 0.0v 324.755n 0.0v 329.745n 0.0v 329.755n 0.0v 334.745n 0.0v 334.755n 0.0v 339.745n 0.0v 339.755n 0.0v 344.745n 0.0v 344.755n 0.0v 349.745n 0.0v 349.755n 0.0v 354.745n 0.0v 354.755n 1.1v 359.745n 1.1v 359.755n 1.1v 364.745n 1.1v 364.755n 1.1v 369.745n 1.1v 369.755n 1.1v 374.745n 1.1v 374.755n 1.1v 379.745n 1.1v 379.755n 0.0v 384.745n 0.0v 384.755n 0.0v 389.745n 0.0v 389.755n 0.0v 394.745n 0.0v 394.755n 0.0v 399.745n 0.0v 399.755n 0.0v 404.745n 0.0v 404.755n 0.0v 409.745n 0.0v 409.755n 0.0v 414.745n 0.0v 414.755n 0.0v 419.745n 0.0v 419.755n 0.0v 424.745n 0.0v 424.755n 0.0v 429.745n 0.0v 429.755n 0.0v 434.745n 0.0v 434.755n 0.0v 439.745n 0.0v 439.755n 0.0v 444.745n 0.0v 444.755n 0.0v 449.745n 0.0v 449.755n 0.0v 454.745n 0.0v 454.755n 0.0v 459.745n 0.0v 459.755n 0.0v 464.745n 0.0v 464.755n 0.0v 469.745n 0.0v 469.755n 0.0v 474.745n 0.0v 474.755n 0.0v 479.745n 0.0v 479.755n 0.0v 484.745n 0.0v 484.755n 0.0v 489.745n 0.0v 489.755n 0.0v 494.745n 0.0v 494.755n 1.1v 499.745n 1.1v 499.755n 1.1v 504.745n 1.1v 504.755n 1.1v 509.745n 1.1v 509.755n 1.1v 514.745n 1.1v 514.755n 1.1v 519.745n 1.1v 519.755n 0.0v 524.745n 0.0v 524.755n 0.0v 529.745n 0.0v 529.755n 0.0v 534.745n 0.0v 534.755n 1.1v 539.745n 1.1v 539.755n 1.1v 544.745n 1.1v 544.755n 1.1v 549.745n 1.1v 549.755n 1.1v 554.745n 1.1v 554.755n 1.1v 559.745n 1.1v 559.755n 1.1v 564.745n 1.1v 564.755n 1.1v 569.745n 1.1v 569.755n 1.1v 574.745n 1.1v 574.755n 1.1v 579.745n 1.1v 579.755n 1.1v 584.745n 1.1v 584.755n 1.1v 589.745n 1.1v 589.755n 1.1v 594.745n 1.1v 594.755n 1.1v 599.745n 1.1v 599.755n 1.1v 604.745n 1.1v 604.755n 1.1v 609.745n 1.1v 609.755n 1.1v 614.745n 1.1v 614.755n 1.1v 619.745n 1.1v 619.755n 0.0v 624.745n 0.0v 624.755n 0.0v 629.745n 0.0v 629.755n 0.0v 634.745n 0.0v 634.755n 0.0v 639.745n 0.0v 639.755n 0.0v 644.745n 0.0v 644.755n 1.1v 649.745n 1.1v 649.755n 1.1v 654.745n 1.1v 654.755n 1.1v 659.745n 1.1v 659.755n 0.0v 664.745n 0.0v 664.755n 1.1v 669.745n 1.1v 669.755n 1.1v 674.745n 1.1v 674.755n 1.1v 679.745n 1.1v 679.755n 0.0v 684.745n 0.0v 684.755n 0.0v 689.745n 0.0v 689.755n 0.0v 694.745n 0.0v 694.755n 0.0v 699.745n 0.0v 699.755n 0.0v 704.745n 0.0v 704.755n 0.0v 709.745n 0.0v 709.755n 1.1v 714.745n 1.1v 714.755n 0.0v 719.745n 0.0v 719.755n 0.0v 724.745n 0.0v 724.755n 0.0v 729.745n 0.0v 729.755n 0.0v 734.745n 0.0v 734.755n 0.0v 739.745n 0.0v 739.755n 1.1v 744.745n 1.1v 744.755n 1.1v 749.745n 1.1v 749.755n 1.1v 754.745n 1.1v 754.755n 1.1v 759.745n 1.1v 759.755n 0.0v 764.745n 0.0v 764.755n 0.0v 769.745n 0.0v 769.755n 1.1v 774.745n 1.1v 774.755n 1.1v 779.745n 1.1v 779.755n 1.1v 784.745n 1.1v 784.755n 1.1v 789.745n 1.1v 789.755n 0.0v 794.745n 0.0v 794.755n 1.1v 799.745n 1.1v 799.755n 1.1v 804.745n 1.1v 804.755n 1.1v 809.745n 1.1v 809.755n 1.1v 814.745n 1.1v 814.755n 1.1v 819.745n 1.1v 819.755n 1.1v 824.745n 1.1v 824.755n 1.1v 829.745n 1.1v 829.755n 1.1v 834.745n 1.1v 834.755n 1.1v 839.745n 1.1v 839.755n 1.1v 844.745n 1.1v 844.755n 1.1v 849.745n 1.1v 849.755n 1.1v 854.745n 1.1v 854.755n 1.1v 859.745n 1.1v 859.755n 1.1v 864.745n 1.1v 864.755n 1.1v 869.745n 1.1v 869.755n 1.1v 874.745n 1.1v 874.755n 0.0v 879.745n 0.0v 879.755n 0.0v 884.745n 0.0v 884.755n 0.0v 889.745n 0.0v 889.755n 1.1v 894.745n 1.1v 894.755n 1.1v 899.745n 1.1v 899.755n 1.1v 904.745n 1.1v 904.755n 1.1v 909.745n 1.1v 909.755n 0.0v 914.745n 0.0v 914.755n 0.0v 919.745n 0.0v 919.755n 0.0v 924.745n 0.0v 924.755n 0.0v 929.745n 0.0v 929.755n 0.0v 934.745n 0.0v 934.755n 0.0v 939.745n 0.0v 939.755n 0.0v 944.745n 0.0v 944.755n 0.0v 949.745n 0.0v 949.755n 0.0v 954.745n 0.0v 954.755n 0.0v 959.745n 0.0v 959.755n 0.0v 964.745n 0.0v 964.755n 0.0v 969.745n 0.0v 969.755n 0.0v 974.745n 0.0v 974.755n 0.0v 979.745n 0.0v 979.755n 0.0v 984.745n 0.0v 984.755n 0.0v 989.745n 0.0v 989.755n 0.0v 994.745n 0.0v 994.755n 0.0v 999.745n 0.0v 999.755n 0.0v 1004.745n 0.0v 1004.755n 0.0v 1009.745n 0.0v 1009.755n 0.0v 1014.745n 0.0v 1014.755n 0.0v 1019.745n 0.0v 1019.755n 0.0v 1024.745n 0.0v 1024.755n 0.0v )
* (time, data): [(0, 0), (5, 0), (10, 1), (15, 0), (20, 0), (25, 0), (30, 1), (35, 1), (40, 1), (45, 1), (50, 1), (55, 1), (60, 1), (65, 0), (70, 0), (75, 0), (80, 1), (85, 1), (90, 1), (95, 1), (100, 1), (105, 1), (110, 1), (115, 1), (120, 1), (125, 1), (130, 1), (135, 0), (140, 1), (145, 1), (150, 1), (155, 1), (160, 1), (165, 1), (170, 1), (175, 1), (180, 1), (185, 1), (190, 1), (195, 1), (200, 1), (205, 1), (210, 1), (215, 1), (220, 1), (225, 0), (230, 0), (235, 0), (240, 0), (245, 0), (250, 0), (255, 0), (260, 0), (265, 1), (270, 0), (275, 0), (280, 0), (285, 0), (290, 0), (295, 0), (300, 0), (305, 0), (310, 0), (315, 0), (320, 0), (325, 0), (330, 0), (335, 0), (340, 0), (345, 0), (350, 0), (355, 0), (360, 0), (365, 0), (370, 0), (375, 0), (380, 1), (385, 1), (390, 1), (395, 1), (400, 1), (405, 1), (410, 1), (415, 1), (420, 0), (425, 0), (430, 0), (435, 0), (440, 0), (445, 0), (450, 0), (455, 0), (460, 0), (465, 0), (470, 1), (475, 1), (480, 1), (485, 1), (490, 1), (495, 1), (500, 1), (505, 1), (510, 1), (515, 1), (520, 0), (525, 0), (530, 0), (535, 0), (540, 0), (545, 0), (550, 0), (555, 0), (560, 0), (565, 0), (570, 0), (575, 0), (580, 0), (585, 0), (590, 0), (595, 0), (600, 0), (605, 0), (610, 0), (615, 0), (620, 0), (625, 0), (630, 0), (635, 0), (640, 0), (645, 0), (650, 0), (655, 0), (660, 1), (665, 1), (670, 1), (675, 0), (680, 0), (685, 0), (690, 0), (695, 0), (700, 0), (705, 0), (710, 1), (715, 1), (720, 1), (725, 1), (730, 1), (735, 1), (740, 0), (745, 0), (750, 0), (755, 0), (760, 1), (765, 1), (770, 1), (775, 1), (780, 1), (785, 0), (790, 1), (795, 1), (800, 1), (805, 1), (810, 1), (815, 1), (820, 1), (825, 1), (830, 1), (835, 1), (840, 1), (845, 0), (850, 0), (855, 0), (860, 0), (865, 1), (870, 1), (875, 1), (880, 1), (885, 1), (890, 0), (895, 0), (900, 0), (905, 0), (910, 0), (915, 0), (920, 0), (925, 0), (930, 0), (935, 0), (940, 0), (945, 0), (950, 0), (955, 0), (960, 0), (965, 0), (970, 0), (975, 0), (980, 0), (985, 0), (990, 0), (995, 1), (1000, 1), (1005, 0), (1010, 0), (1015, 0), (1020, 0), (1025, 0)]
Vdin0_13  din0_13  0 PWL (0n 0.0v 4.745n 0.0v 4.755n 0.0v 9.745n 0.0v 9.755n 1.1v 14.745n 1.1v 14.755n 0.0v 19.745n 0.0v 19.755n 0.0v 24.745n 0.0v 24.755n 0.0v 29.745n 0.0v 29.755n 1.1v 34.745n 1.1v 34.755n 1.1v 39.745n 1.1v 39.755n 1.1v 44.745n 1.1v 44.755n 1.1v 49.745n 1.1v 49.755n 1.1v 54.745n 1.1v 54.755n 1.1v 59.745n 1.1v 59.755n 1.1v 64.745n 1.1v 64.755n 0.0v 69.745n 0.0v 69.755n 0.0v 74.745n 0.0v 74.755n 0.0v 79.745n 0.0v 79.755n 1.1v 84.745n 1.1v 84.755n 1.1v 89.745n 1.1v 89.755n 1.1v 94.745n 1.1v 94.755n 1.1v 99.745n 1.1v 99.755n 1.1v 104.745n 1.1v 104.755n 1.1v 109.745n 1.1v 109.755n 1.1v 114.745n 1.1v 114.755n 1.1v 119.745n 1.1v 119.755n 1.1v 124.745n 1.1v 124.755n 1.1v 129.745n 1.1v 129.755n 1.1v 134.745n 1.1v 134.755n 0.0v 139.745n 0.0v 139.755n 1.1v 144.745n 1.1v 144.755n 1.1v 149.745n 1.1v 149.755n 1.1v 154.745n 1.1v 154.755n 1.1v 159.745n 1.1v 159.755n 1.1v 164.745n 1.1v 164.755n 1.1v 169.745n 1.1v 169.755n 1.1v 174.745n 1.1v 174.755n 1.1v 179.745n 1.1v 179.755n 1.1v 184.745n 1.1v 184.755n 1.1v 189.745n 1.1v 189.755n 1.1v 194.745n 1.1v 194.755n 1.1v 199.745n 1.1v 199.755n 1.1v 204.745n 1.1v 204.755n 1.1v 209.745n 1.1v 209.755n 1.1v 214.745n 1.1v 214.755n 1.1v 219.745n 1.1v 219.755n 1.1v 224.745n 1.1v 224.755n 0.0v 229.745n 0.0v 229.755n 0.0v 234.745n 0.0v 234.755n 0.0v 239.745n 0.0v 239.755n 0.0v 244.745n 0.0v 244.755n 0.0v 249.745n 0.0v 249.755n 0.0v 254.745n 0.0v 254.755n 0.0v 259.745n 0.0v 259.755n 0.0v 264.745n 0.0v 264.755n 1.1v 269.745n 1.1v 269.755n 0.0v 274.745n 0.0v 274.755n 0.0v 279.745n 0.0v 279.755n 0.0v 284.745n 0.0v 284.755n 0.0v 289.745n 0.0v 289.755n 0.0v 294.745n 0.0v 294.755n 0.0v 299.745n 0.0v 299.755n 0.0v 304.745n 0.0v 304.755n 0.0v 309.745n 0.0v 309.755n 0.0v 314.745n 0.0v 314.755n 0.0v 319.745n 0.0v 319.755n 0.0v 324.745n 0.0v 324.755n 0.0v 329.745n 0.0v 329.755n 0.0v 334.745n 0.0v 334.755n 0.0v 339.745n 0.0v 339.755n 0.0v 344.745n 0.0v 344.755n 0.0v 349.745n 0.0v 349.755n 0.0v 354.745n 0.0v 354.755n 0.0v 359.745n 0.0v 359.755n 0.0v 364.745n 0.0v 364.755n 0.0v 369.745n 0.0v 369.755n 0.0v 374.745n 0.0v 374.755n 0.0v 379.745n 0.0v 379.755n 1.1v 384.745n 1.1v 384.755n 1.1v 389.745n 1.1v 389.755n 1.1v 394.745n 1.1v 394.755n 1.1v 399.745n 1.1v 399.755n 1.1v 404.745n 1.1v 404.755n 1.1v 409.745n 1.1v 409.755n 1.1v 414.745n 1.1v 414.755n 1.1v 419.745n 1.1v 419.755n 0.0v 424.745n 0.0v 424.755n 0.0v 429.745n 0.0v 429.755n 0.0v 434.745n 0.0v 434.755n 0.0v 439.745n 0.0v 439.755n 0.0v 444.745n 0.0v 444.755n 0.0v 449.745n 0.0v 449.755n 0.0v 454.745n 0.0v 454.755n 0.0v 459.745n 0.0v 459.755n 0.0v 464.745n 0.0v 464.755n 0.0v 469.745n 0.0v 469.755n 1.1v 474.745n 1.1v 474.755n 1.1v 479.745n 1.1v 479.755n 1.1v 484.745n 1.1v 484.755n 1.1v 489.745n 1.1v 489.755n 1.1v 494.745n 1.1v 494.755n 1.1v 499.745n 1.1v 499.755n 1.1v 504.745n 1.1v 504.755n 1.1v 509.745n 1.1v 509.755n 1.1v 514.745n 1.1v 514.755n 1.1v 519.745n 1.1v 519.755n 0.0v 524.745n 0.0v 524.755n 0.0v 529.745n 0.0v 529.755n 0.0v 534.745n 0.0v 534.755n 0.0v 539.745n 0.0v 539.755n 0.0v 544.745n 0.0v 544.755n 0.0v 549.745n 0.0v 549.755n 0.0v 554.745n 0.0v 554.755n 0.0v 559.745n 0.0v 559.755n 0.0v 564.745n 0.0v 564.755n 0.0v 569.745n 0.0v 569.755n 0.0v 574.745n 0.0v 574.755n 0.0v 579.745n 0.0v 579.755n 0.0v 584.745n 0.0v 584.755n 0.0v 589.745n 0.0v 589.755n 0.0v 594.745n 0.0v 594.755n 0.0v 599.745n 0.0v 599.755n 0.0v 604.745n 0.0v 604.755n 0.0v 609.745n 0.0v 609.755n 0.0v 614.745n 0.0v 614.755n 0.0v 619.745n 0.0v 619.755n 0.0v 624.745n 0.0v 624.755n 0.0v 629.745n 0.0v 629.755n 0.0v 634.745n 0.0v 634.755n 0.0v 639.745n 0.0v 639.755n 0.0v 644.745n 0.0v 644.755n 0.0v 649.745n 0.0v 649.755n 0.0v 654.745n 0.0v 654.755n 0.0v 659.745n 0.0v 659.755n 1.1v 664.745n 1.1v 664.755n 1.1v 669.745n 1.1v 669.755n 1.1v 674.745n 1.1v 674.755n 0.0v 679.745n 0.0v 679.755n 0.0v 684.745n 0.0v 684.755n 0.0v 689.745n 0.0v 689.755n 0.0v 694.745n 0.0v 694.755n 0.0v 699.745n 0.0v 699.755n 0.0v 704.745n 0.0v 704.755n 0.0v 709.745n 0.0v 709.755n 1.1v 714.745n 1.1v 714.755n 1.1v 719.745n 1.1v 719.755n 1.1v 724.745n 1.1v 724.755n 1.1v 729.745n 1.1v 729.755n 1.1v 734.745n 1.1v 734.755n 1.1v 739.745n 1.1v 739.755n 0.0v 744.745n 0.0v 744.755n 0.0v 749.745n 0.0v 749.755n 0.0v 754.745n 0.0v 754.755n 0.0v 759.745n 0.0v 759.755n 1.1v 764.745n 1.1v 764.755n 1.1v 769.745n 1.1v 769.755n 1.1v 774.745n 1.1v 774.755n 1.1v 779.745n 1.1v 779.755n 1.1v 784.745n 1.1v 784.755n 0.0v 789.745n 0.0v 789.755n 1.1v 794.745n 1.1v 794.755n 1.1v 799.745n 1.1v 799.755n 1.1v 804.745n 1.1v 804.755n 1.1v 809.745n 1.1v 809.755n 1.1v 814.745n 1.1v 814.755n 1.1v 819.745n 1.1v 819.755n 1.1v 824.745n 1.1v 824.755n 1.1v 829.745n 1.1v 829.755n 1.1v 834.745n 1.1v 834.755n 1.1v 839.745n 1.1v 839.755n 1.1v 844.745n 1.1v 844.755n 0.0v 849.745n 0.0v 849.755n 0.0v 854.745n 0.0v 854.755n 0.0v 859.745n 0.0v 859.755n 0.0v 864.745n 0.0v 864.755n 1.1v 869.745n 1.1v 869.755n 1.1v 874.745n 1.1v 874.755n 1.1v 879.745n 1.1v 879.755n 1.1v 884.745n 1.1v 884.755n 1.1v 889.745n 1.1v 889.755n 0.0v 894.745n 0.0v 894.755n 0.0v 899.745n 0.0v 899.755n 0.0v 904.745n 0.0v 904.755n 0.0v 909.745n 0.0v 909.755n 0.0v 914.745n 0.0v 914.755n 0.0v 919.745n 0.0v 919.755n 0.0v 924.745n 0.0v 924.755n 0.0v 929.745n 0.0v 929.755n 0.0v 934.745n 0.0v 934.755n 0.0v 939.745n 0.0v 939.755n 0.0v 944.745n 0.0v 944.755n 0.0v 949.745n 0.0v 949.755n 0.0v 954.745n 0.0v 954.755n 0.0v 959.745n 0.0v 959.755n 0.0v 964.745n 0.0v 964.755n 0.0v 969.745n 0.0v 969.755n 0.0v 974.745n 0.0v 974.755n 0.0v 979.745n 0.0v 979.755n 0.0v 984.745n 0.0v 984.755n 0.0v 989.745n 0.0v 989.755n 0.0v 994.745n 0.0v 994.755n 1.1v 999.745n 1.1v 999.755n 1.1v 1004.745n 1.1v 1004.755n 0.0v 1009.745n 0.0v 1009.755n 0.0v 1014.745n 0.0v 1014.755n 0.0v 1019.745n 0.0v 1019.755n 0.0v 1024.745n 0.0v 1024.755n 0.0v )
* (time, data): [(0, 0), (5, 1), (10, 0), (15, 0), (20, 0), (25, 0), (30, 1), (35, 1), (40, 1), (45, 1), (50, 1), (55, 1), (60, 0), (65, 1), (70, 1), (75, 1), (80, 1), (85, 1), (90, 1), (95, 0), (100, 0), (105, 0), (110, 0), (115, 0), (120, 0), (125, 0), (130, 1), (135, 1), (140, 0), (145, 0), (150, 1), (155, 0), (160, 0), (165, 0), (170, 0), (175, 0), (180, 0), (185, 0), (190, 0), (195, 0), (200, 0), (205, 0), (210, 0), (215, 0), (220, 0), (225, 0), (230, 0), (235, 0), (240, 0), (245, 0), (250, 0), (255, 0), (260, 0), (265, 0), (270, 1), (275, 1), (280, 1), (285, 1), (290, 1), (295, 1), (300, 1), (305, 1), (310, 1), (315, 1), (320, 1), (325, 1), (330, 1), (335, 1), (340, 1), (345, 1), (350, 1), (355, 1), (360, 1), (365, 1), (370, 1), (375, 1), (380, 1), (385, 1), (390, 1), (395, 1), (400, 1), (405, 1), (410, 1), (415, 1), (420, 1), (425, 1), (430, 1), (435, 1), (440, 1), (445, 1), (450, 1), (455, 1), (460, 1), (465, 1), (470, 1), (475, 0), (480, 0), (485, 0), (490, 0), (495, 0), (500, 0), (505, 0), (510, 0), (515, 0), (520, 1), (525, 1), (530, 1), (535, 1), (540, 1), (545, 1), (550, 1), (555, 1), (560, 1), (565, 1), (570, 1), (575, 1), (580, 1), (585, 1), (590, 1), (595, 1), (600, 1), (605, 1), (610, 1), (615, 1), (620, 0), (625, 0), (630, 0), (635, 0), (640, 0), (645, 1), (650, 1), (655, 1), (660, 0), (665, 0), (670, 0), (675, 1), (680, 1), (685, 1), (690, 1), (695, 1), (700, 1), (705, 1), (710, 1), (715, 0), (720, 0), (725, 0), (730, 0), (735, 0), (740, 1), (745, 1), (750, 1), (755, 1), (760, 1), (765, 1), (770, 1), (775, 1), (780, 1), (785, 0), (790, 1), (795, 0), (800, 0), (805, 0), (810, 0), (815, 0), (820, 0), (825, 0), (830, 0), (835, 0), (840, 0), (845, 0), (850, 0), (855, 0), (860, 0), (865, 1), (870, 1), (875, 0), (880, 0), (885, 0), (890, 1), (895, 1), (900, 0), (905, 0), (910, 1), (915, 1), (920, 1), (925, 1), (930, 1), (935, 1), (940, 1), (945, 1), (950, 1), (955, 1), (960, 1), (965, 1), (970, 1), (975, 0), (980, 0), (985, 0), (990, 0), (995, 0), (1000, 0), (1005, 1), (1010, 1), (1015, 1), (1020, 1), (1025, 1)]
Vdin0_14  din0_14  0 PWL (0n 0.0v 4.745n 0.0v 4.755n 1.1v 9.745n 1.1v 9.755n 0.0v 14.745n 0.0v 14.755n 0.0v 19.745n 0.0v 19.755n 0.0v 24.745n 0.0v 24.755n 0.0v 29.745n 0.0v 29.755n 1.1v 34.745n 1.1v 34.755n 1.1v 39.745n 1.1v 39.755n 1.1v 44.745n 1.1v 44.755n 1.1v 49.745n 1.1v 49.755n 1.1v 54.745n 1.1v 54.755n 1.1v 59.745n 1.1v 59.755n 0.0v 64.745n 0.0v 64.755n 1.1v 69.745n 1.1v 69.755n 1.1v 74.745n 1.1v 74.755n 1.1v 79.745n 1.1v 79.755n 1.1v 84.745n 1.1v 84.755n 1.1v 89.745n 1.1v 89.755n 1.1v 94.745n 1.1v 94.755n 0.0v 99.745n 0.0v 99.755n 0.0v 104.745n 0.0v 104.755n 0.0v 109.745n 0.0v 109.755n 0.0v 114.745n 0.0v 114.755n 0.0v 119.745n 0.0v 119.755n 0.0v 124.745n 0.0v 124.755n 0.0v 129.745n 0.0v 129.755n 1.1v 134.745n 1.1v 134.755n 1.1v 139.745n 1.1v 139.755n 0.0v 144.745n 0.0v 144.755n 0.0v 149.745n 0.0v 149.755n 1.1v 154.745n 1.1v 154.755n 0.0v 159.745n 0.0v 159.755n 0.0v 164.745n 0.0v 164.755n 0.0v 169.745n 0.0v 169.755n 0.0v 174.745n 0.0v 174.755n 0.0v 179.745n 0.0v 179.755n 0.0v 184.745n 0.0v 184.755n 0.0v 189.745n 0.0v 189.755n 0.0v 194.745n 0.0v 194.755n 0.0v 199.745n 0.0v 199.755n 0.0v 204.745n 0.0v 204.755n 0.0v 209.745n 0.0v 209.755n 0.0v 214.745n 0.0v 214.755n 0.0v 219.745n 0.0v 219.755n 0.0v 224.745n 0.0v 224.755n 0.0v 229.745n 0.0v 229.755n 0.0v 234.745n 0.0v 234.755n 0.0v 239.745n 0.0v 239.755n 0.0v 244.745n 0.0v 244.755n 0.0v 249.745n 0.0v 249.755n 0.0v 254.745n 0.0v 254.755n 0.0v 259.745n 0.0v 259.755n 0.0v 264.745n 0.0v 264.755n 0.0v 269.745n 0.0v 269.755n 1.1v 274.745n 1.1v 274.755n 1.1v 279.745n 1.1v 279.755n 1.1v 284.745n 1.1v 284.755n 1.1v 289.745n 1.1v 289.755n 1.1v 294.745n 1.1v 294.755n 1.1v 299.745n 1.1v 299.755n 1.1v 304.745n 1.1v 304.755n 1.1v 309.745n 1.1v 309.755n 1.1v 314.745n 1.1v 314.755n 1.1v 319.745n 1.1v 319.755n 1.1v 324.745n 1.1v 324.755n 1.1v 329.745n 1.1v 329.755n 1.1v 334.745n 1.1v 334.755n 1.1v 339.745n 1.1v 339.755n 1.1v 344.745n 1.1v 344.755n 1.1v 349.745n 1.1v 349.755n 1.1v 354.745n 1.1v 354.755n 1.1v 359.745n 1.1v 359.755n 1.1v 364.745n 1.1v 364.755n 1.1v 369.745n 1.1v 369.755n 1.1v 374.745n 1.1v 374.755n 1.1v 379.745n 1.1v 379.755n 1.1v 384.745n 1.1v 384.755n 1.1v 389.745n 1.1v 389.755n 1.1v 394.745n 1.1v 394.755n 1.1v 399.745n 1.1v 399.755n 1.1v 404.745n 1.1v 404.755n 1.1v 409.745n 1.1v 409.755n 1.1v 414.745n 1.1v 414.755n 1.1v 419.745n 1.1v 419.755n 1.1v 424.745n 1.1v 424.755n 1.1v 429.745n 1.1v 429.755n 1.1v 434.745n 1.1v 434.755n 1.1v 439.745n 1.1v 439.755n 1.1v 444.745n 1.1v 444.755n 1.1v 449.745n 1.1v 449.755n 1.1v 454.745n 1.1v 454.755n 1.1v 459.745n 1.1v 459.755n 1.1v 464.745n 1.1v 464.755n 1.1v 469.745n 1.1v 469.755n 1.1v 474.745n 1.1v 474.755n 0.0v 479.745n 0.0v 479.755n 0.0v 484.745n 0.0v 484.755n 0.0v 489.745n 0.0v 489.755n 0.0v 494.745n 0.0v 494.755n 0.0v 499.745n 0.0v 499.755n 0.0v 504.745n 0.0v 504.755n 0.0v 509.745n 0.0v 509.755n 0.0v 514.745n 0.0v 514.755n 0.0v 519.745n 0.0v 519.755n 1.1v 524.745n 1.1v 524.755n 1.1v 529.745n 1.1v 529.755n 1.1v 534.745n 1.1v 534.755n 1.1v 539.745n 1.1v 539.755n 1.1v 544.745n 1.1v 544.755n 1.1v 549.745n 1.1v 549.755n 1.1v 554.745n 1.1v 554.755n 1.1v 559.745n 1.1v 559.755n 1.1v 564.745n 1.1v 564.755n 1.1v 569.745n 1.1v 569.755n 1.1v 574.745n 1.1v 574.755n 1.1v 579.745n 1.1v 579.755n 1.1v 584.745n 1.1v 584.755n 1.1v 589.745n 1.1v 589.755n 1.1v 594.745n 1.1v 594.755n 1.1v 599.745n 1.1v 599.755n 1.1v 604.745n 1.1v 604.755n 1.1v 609.745n 1.1v 609.755n 1.1v 614.745n 1.1v 614.755n 1.1v 619.745n 1.1v 619.755n 0.0v 624.745n 0.0v 624.755n 0.0v 629.745n 0.0v 629.755n 0.0v 634.745n 0.0v 634.755n 0.0v 639.745n 0.0v 639.755n 0.0v 644.745n 0.0v 644.755n 1.1v 649.745n 1.1v 649.755n 1.1v 654.745n 1.1v 654.755n 1.1v 659.745n 1.1v 659.755n 0.0v 664.745n 0.0v 664.755n 0.0v 669.745n 0.0v 669.755n 0.0v 674.745n 0.0v 674.755n 1.1v 679.745n 1.1v 679.755n 1.1v 684.745n 1.1v 684.755n 1.1v 689.745n 1.1v 689.755n 1.1v 694.745n 1.1v 694.755n 1.1v 699.745n 1.1v 699.755n 1.1v 704.745n 1.1v 704.755n 1.1v 709.745n 1.1v 709.755n 1.1v 714.745n 1.1v 714.755n 0.0v 719.745n 0.0v 719.755n 0.0v 724.745n 0.0v 724.755n 0.0v 729.745n 0.0v 729.755n 0.0v 734.745n 0.0v 734.755n 0.0v 739.745n 0.0v 739.755n 1.1v 744.745n 1.1v 744.755n 1.1v 749.745n 1.1v 749.755n 1.1v 754.745n 1.1v 754.755n 1.1v 759.745n 1.1v 759.755n 1.1v 764.745n 1.1v 764.755n 1.1v 769.745n 1.1v 769.755n 1.1v 774.745n 1.1v 774.755n 1.1v 779.745n 1.1v 779.755n 1.1v 784.745n 1.1v 784.755n 0.0v 789.745n 0.0v 789.755n 1.1v 794.745n 1.1v 794.755n 0.0v 799.745n 0.0v 799.755n 0.0v 804.745n 0.0v 804.755n 0.0v 809.745n 0.0v 809.755n 0.0v 814.745n 0.0v 814.755n 0.0v 819.745n 0.0v 819.755n 0.0v 824.745n 0.0v 824.755n 0.0v 829.745n 0.0v 829.755n 0.0v 834.745n 0.0v 834.755n 0.0v 839.745n 0.0v 839.755n 0.0v 844.745n 0.0v 844.755n 0.0v 849.745n 0.0v 849.755n 0.0v 854.745n 0.0v 854.755n 0.0v 859.745n 0.0v 859.755n 0.0v 864.745n 0.0v 864.755n 1.1v 869.745n 1.1v 869.755n 1.1v 874.745n 1.1v 874.755n 0.0v 879.745n 0.0v 879.755n 0.0v 884.745n 0.0v 884.755n 0.0v 889.745n 0.0v 889.755n 1.1v 894.745n 1.1v 894.755n 1.1v 899.745n 1.1v 899.755n 0.0v 904.745n 0.0v 904.755n 0.0v 909.745n 0.0v 909.755n 1.1v 914.745n 1.1v 914.755n 1.1v 919.745n 1.1v 919.755n 1.1v 924.745n 1.1v 924.755n 1.1v 929.745n 1.1v 929.755n 1.1v 934.745n 1.1v 934.755n 1.1v 939.745n 1.1v 939.755n 1.1v 944.745n 1.1v 944.755n 1.1v 949.745n 1.1v 949.755n 1.1v 954.745n 1.1v 954.755n 1.1v 959.745n 1.1v 959.755n 1.1v 964.745n 1.1v 964.755n 1.1v 969.745n 1.1v 969.755n 1.1v 974.745n 1.1v 974.755n 0.0v 979.745n 0.0v 979.755n 0.0v 984.745n 0.0v 984.755n 0.0v 989.745n 0.0v 989.755n 0.0v 994.745n 0.0v 994.755n 0.0v 999.745n 0.0v 999.755n 0.0v 1004.745n 0.0v 1004.755n 1.1v 1009.745n 1.1v 1009.755n 1.1v 1014.745n 1.1v 1014.755n 1.1v 1019.745n 1.1v 1019.755n 1.1v 1024.745n 1.1v 1024.755n 1.1v )
* (time, data): [(0, 0), (5, 1), (10, 1), (15, 1), (20, 1), (25, 1), (30, 0), (35, 0), (40, 0), (45, 0), (50, 0), (55, 0), (60, 0), (65, 1), (70, 1), (75, 1), (80, 1), (85, 1), (90, 1), (95, 0), (100, 0), (105, 0), (110, 0), (115, 1), (120, 1), (125, 1), (130, 1), (135, 1), (140, 0), (145, 0), (150, 1), (155, 1), (160, 1), (165, 1), (170, 1), (175, 1), (180, 1), (185, 1), (190, 1), (195, 1), (200, 1), (205, 1), (210, 1), (215, 1), (220, 1), (225, 0), (230, 0), (235, 0), (240, 0), (245, 0), (250, 0), (255, 0), (260, 0), (265, 0), (270, 1), (275, 1), (280, 1), (285, 1), (290, 1), (295, 1), (300, 1), (305, 1), (310, 1), (315, 1), (320, 1), (325, 1), (330, 1), (335, 1), (340, 1), (345, 1), (350, 1), (355, 1), (360, 1), (365, 1), (370, 1), (375, 1), (380, 0), (385, 0), (390, 0), (395, 0), (400, 0), (405, 0), (410, 0), (415, 0), (420, 0), (425, 0), (430, 0), (435, 0), (440, 0), (445, 0), (450, 0), (455, 0), (460, 0), (465, 0), (470, 1), (475, 0), (480, 0), (485, 0), (490, 0), (495, 0), (500, 0), (505, 0), (510, 0), (515, 0), (520, 0), (525, 0), (530, 0), (535, 0), (540, 0), (545, 0), (550, 0), (555, 0), (560, 0), (565, 0), (570, 0), (575, 0), (580, 0), (585, 0), (590, 0), (595, 0), (600, 0), (605, 0), (610, 0), (615, 0), (620, 0), (625, 0), (630, 0), (635, 0), (640, 0), (645, 1), (650, 1), (655, 1), (660, 1), (665, 1), (670, 1), (675, 1), (680, 1), (685, 1), (690, 1), (695, 1), (700, 1), (705, 1), (710, 1), (715, 0), (720, 0), (725, 0), (730, 0), (735, 0), (740, 1), (745, 1), (750, 1), (755, 1), (760, 0), (765, 0), (770, 1), (775, 1), (780, 1), (785, 1), (790, 1), (795, 1), (800, 1), (805, 1), (810, 1), (815, 1), (820, 1), (825, 1), (830, 1), (835, 1), (840, 1), (845, 1), (850, 1), (855, 1), (860, 1), (865, 1), (870, 1), (875, 0), (880, 0), (885, 0), (890, 0), (895, 0), (900, 1), (905, 1), (910, 0), (915, 0), (920, 0), (925, 0), (930, 0), (935, 0), (940, 0), (945, 0), (950, 0), (955, 0), (960, 0), (965, 0), (970, 0), (975, 0), (980, 0), (985, 0), (990, 0), (995, 0), (1000, 0), (1005, 1), (1010, 1), (1015, 1), (1020, 1), (1025, 1)]
Vdin0_15  din0_15  0 PWL (0n 0.0v 4.745n 0.0v 4.755n 1.1v 9.745n 1.1v 9.755n 1.1v 14.745n 1.1v 14.755n 1.1v 19.745n 1.1v 19.755n 1.1v 24.745n 1.1v 24.755n 1.1v 29.745n 1.1v 29.755n 0.0v 34.745n 0.0v 34.755n 0.0v 39.745n 0.0v 39.755n 0.0v 44.745n 0.0v 44.755n 0.0v 49.745n 0.0v 49.755n 0.0v 54.745n 0.0v 54.755n 0.0v 59.745n 0.0v 59.755n 0.0v 64.745n 0.0v 64.755n 1.1v 69.745n 1.1v 69.755n 1.1v 74.745n 1.1v 74.755n 1.1v 79.745n 1.1v 79.755n 1.1v 84.745n 1.1v 84.755n 1.1v 89.745n 1.1v 89.755n 1.1v 94.745n 1.1v 94.755n 0.0v 99.745n 0.0v 99.755n 0.0v 104.745n 0.0v 104.755n 0.0v 109.745n 0.0v 109.755n 0.0v 114.745n 0.0v 114.755n 1.1v 119.745n 1.1v 119.755n 1.1v 124.745n 1.1v 124.755n 1.1v 129.745n 1.1v 129.755n 1.1v 134.745n 1.1v 134.755n 1.1v 139.745n 1.1v 139.755n 0.0v 144.745n 0.0v 144.755n 0.0v 149.745n 0.0v 149.755n 1.1v 154.745n 1.1v 154.755n 1.1v 159.745n 1.1v 159.755n 1.1v 164.745n 1.1v 164.755n 1.1v 169.745n 1.1v 169.755n 1.1v 174.745n 1.1v 174.755n 1.1v 179.745n 1.1v 179.755n 1.1v 184.745n 1.1v 184.755n 1.1v 189.745n 1.1v 189.755n 1.1v 194.745n 1.1v 194.755n 1.1v 199.745n 1.1v 199.755n 1.1v 204.745n 1.1v 204.755n 1.1v 209.745n 1.1v 209.755n 1.1v 214.745n 1.1v 214.755n 1.1v 219.745n 1.1v 219.755n 1.1v 224.745n 1.1v 224.755n 0.0v 229.745n 0.0v 229.755n 0.0v 234.745n 0.0v 234.755n 0.0v 239.745n 0.0v 239.755n 0.0v 244.745n 0.0v 244.755n 0.0v 249.745n 0.0v 249.755n 0.0v 254.745n 0.0v 254.755n 0.0v 259.745n 0.0v 259.755n 0.0v 264.745n 0.0v 264.755n 0.0v 269.745n 0.0v 269.755n 1.1v 274.745n 1.1v 274.755n 1.1v 279.745n 1.1v 279.755n 1.1v 284.745n 1.1v 284.755n 1.1v 289.745n 1.1v 289.755n 1.1v 294.745n 1.1v 294.755n 1.1v 299.745n 1.1v 299.755n 1.1v 304.745n 1.1v 304.755n 1.1v 309.745n 1.1v 309.755n 1.1v 314.745n 1.1v 314.755n 1.1v 319.745n 1.1v 319.755n 1.1v 324.745n 1.1v 324.755n 1.1v 329.745n 1.1v 329.755n 1.1v 334.745n 1.1v 334.755n 1.1v 339.745n 1.1v 339.755n 1.1v 344.745n 1.1v 344.755n 1.1v 349.745n 1.1v 349.755n 1.1v 354.745n 1.1v 354.755n 1.1v 359.745n 1.1v 359.755n 1.1v 364.745n 1.1v 364.755n 1.1v 369.745n 1.1v 369.755n 1.1v 374.745n 1.1v 374.755n 1.1v 379.745n 1.1v 379.755n 0.0v 384.745n 0.0v 384.755n 0.0v 389.745n 0.0v 389.755n 0.0v 394.745n 0.0v 394.755n 0.0v 399.745n 0.0v 399.755n 0.0v 404.745n 0.0v 404.755n 0.0v 409.745n 0.0v 409.755n 0.0v 414.745n 0.0v 414.755n 0.0v 419.745n 0.0v 419.755n 0.0v 424.745n 0.0v 424.755n 0.0v 429.745n 0.0v 429.755n 0.0v 434.745n 0.0v 434.755n 0.0v 439.745n 0.0v 439.755n 0.0v 444.745n 0.0v 444.755n 0.0v 449.745n 0.0v 449.755n 0.0v 454.745n 0.0v 454.755n 0.0v 459.745n 0.0v 459.755n 0.0v 464.745n 0.0v 464.755n 0.0v 469.745n 0.0v 469.755n 1.1v 474.745n 1.1v 474.755n 0.0v 479.745n 0.0v 479.755n 0.0v 484.745n 0.0v 484.755n 0.0v 489.745n 0.0v 489.755n 0.0v 494.745n 0.0v 494.755n 0.0v 499.745n 0.0v 499.755n 0.0v 504.745n 0.0v 504.755n 0.0v 509.745n 0.0v 509.755n 0.0v 514.745n 0.0v 514.755n 0.0v 519.745n 0.0v 519.755n 0.0v 524.745n 0.0v 524.755n 0.0v 529.745n 0.0v 529.755n 0.0v 534.745n 0.0v 534.755n 0.0v 539.745n 0.0v 539.755n 0.0v 544.745n 0.0v 544.755n 0.0v 549.745n 0.0v 549.755n 0.0v 554.745n 0.0v 554.755n 0.0v 559.745n 0.0v 559.755n 0.0v 564.745n 0.0v 564.755n 0.0v 569.745n 0.0v 569.755n 0.0v 574.745n 0.0v 574.755n 0.0v 579.745n 0.0v 579.755n 0.0v 584.745n 0.0v 584.755n 0.0v 589.745n 0.0v 589.755n 0.0v 594.745n 0.0v 594.755n 0.0v 599.745n 0.0v 599.755n 0.0v 604.745n 0.0v 604.755n 0.0v 609.745n 0.0v 609.755n 0.0v 614.745n 0.0v 614.755n 0.0v 619.745n 0.0v 619.755n 0.0v 624.745n 0.0v 624.755n 0.0v 629.745n 0.0v 629.755n 0.0v 634.745n 0.0v 634.755n 0.0v 639.745n 0.0v 639.755n 0.0v 644.745n 0.0v 644.755n 1.1v 649.745n 1.1v 649.755n 1.1v 654.745n 1.1v 654.755n 1.1v 659.745n 1.1v 659.755n 1.1v 664.745n 1.1v 664.755n 1.1v 669.745n 1.1v 669.755n 1.1v 674.745n 1.1v 674.755n 1.1v 679.745n 1.1v 679.755n 1.1v 684.745n 1.1v 684.755n 1.1v 689.745n 1.1v 689.755n 1.1v 694.745n 1.1v 694.755n 1.1v 699.745n 1.1v 699.755n 1.1v 704.745n 1.1v 704.755n 1.1v 709.745n 1.1v 709.755n 1.1v 714.745n 1.1v 714.755n 0.0v 719.745n 0.0v 719.755n 0.0v 724.745n 0.0v 724.755n 0.0v 729.745n 0.0v 729.755n 0.0v 734.745n 0.0v 734.755n 0.0v 739.745n 0.0v 739.755n 1.1v 744.745n 1.1v 744.755n 1.1v 749.745n 1.1v 749.755n 1.1v 754.745n 1.1v 754.755n 1.1v 759.745n 1.1v 759.755n 0.0v 764.745n 0.0v 764.755n 0.0v 769.745n 0.0v 769.755n 1.1v 774.745n 1.1v 774.755n 1.1v 779.745n 1.1v 779.755n 1.1v 784.745n 1.1v 784.755n 1.1v 789.745n 1.1v 789.755n 1.1v 794.745n 1.1v 794.755n 1.1v 799.745n 1.1v 799.755n 1.1v 804.745n 1.1v 804.755n 1.1v 809.745n 1.1v 809.755n 1.1v 814.745n 1.1v 814.755n 1.1v 819.745n 1.1v 819.755n 1.1v 824.745n 1.1v 824.755n 1.1v 829.745n 1.1v 829.755n 1.1v 834.745n 1.1v 834.755n 1.1v 839.745n 1.1v 839.755n 1.1v 844.745n 1.1v 844.755n 1.1v 849.745n 1.1v 849.755n 1.1v 854.745n 1.1v 854.755n 1.1v 859.745n 1.1v 859.755n 1.1v 864.745n 1.1v 864.755n 1.1v 869.745n 1.1v 869.755n 1.1v 874.745n 1.1v 874.755n 0.0v 879.745n 0.0v 879.755n 0.0v 884.745n 0.0v 884.755n 0.0v 889.745n 0.0v 889.755n 0.0v 894.745n 0.0v 894.755n 0.0v 899.745n 0.0v 899.755n 1.1v 904.745n 1.1v 904.755n 1.1v 909.745n 1.1v 909.755n 0.0v 914.745n 0.0v 914.755n 0.0v 919.745n 0.0v 919.755n 0.0v 924.745n 0.0v 924.755n 0.0v 929.745n 0.0v 929.755n 0.0v 934.745n 0.0v 934.755n 0.0v 939.745n 0.0v 939.755n 0.0v 944.745n 0.0v 944.755n 0.0v 949.745n 0.0v 949.755n 0.0v 954.745n 0.0v 954.755n 0.0v 959.745n 0.0v 959.755n 0.0v 964.745n 0.0v 964.755n 0.0v 969.745n 0.0v 969.755n 0.0v 974.745n 0.0v 974.755n 0.0v 979.745n 0.0v 979.755n 0.0v 984.745n 0.0v 984.755n 0.0v 989.745n 0.0v 989.755n 0.0v 994.745n 0.0v 994.755n 0.0v 999.745n 0.0v 999.755n 0.0v 1004.745n 0.0v 1004.755n 1.1v 1009.745n 1.1v 1009.755n 1.1v 1014.745n 1.1v 1014.755n 1.1v 1019.745n 1.1v 1019.755n 1.1v 1024.745n 1.1v 1024.755n 1.1v )
* (time, data): [(0, 0), (5, 0), (10, 1), (15, 1), (20, 1), (25, 1), (30, 1), (35, 1), (40, 1), (45, 1), (50, 1), (55, 1), (60, 1), (65, 0), (70, 0), (75, 0), (80, 0), (85, 0), (90, 0), (95, 0), (100, 0), (105, 0), (110, 1), (115, 0), (120, 0), (125, 0), (130, 1), (135, 0), (140, 1), (145, 1), (150, 1), (155, 1), (160, 1), (165, 1), (170, 1), (175, 1), (180, 1), (185, 1), (190, 1), (195, 1), (200, 1), (205, 1), (210, 1), (215, 1), (220, 1), (225, 1), (230, 1), (235, 1), (240, 1), (245, 1), (250, 1), (255, 1), (260, 1), (265, 1), (270, 0), (275, 0), (280, 0), (285, 0), (290, 0), (295, 0), (300, 0), (305, 0), (310, 0), (315, 0), (320, 0), (325, 0), (330, 0), (335, 0), (340, 0), (345, 0), (350, 0), (355, 1), (360, 1), (365, 1), (370, 1), (375, 1), (380, 1), (385, 1), (390, 1), (395, 1), (400, 1), (405, 1), (410, 1), (415, 1), (420, 1), (425, 1), (430, 1), (435, 1), (440, 1), (445, 1), (450, 1), (455, 1), (460, 1), (465, 1), (470, 1), (475, 1), (480, 1), (485, 1), (490, 1), (495, 1), (500, 1), (505, 1), (510, 1), (515, 1), (520, 0), (525, 0), (530, 0), (535, 0), (540, 0), (545, 0), (550, 0), (555, 0), (560, 0), (565, 0), (570, 0), (575, 0), (580, 0), (585, 0), (590, 0), (595, 0), (600, 0), (605, 0), (610, 0), (615, 0), (620, 1), (625, 1), (630, 1), (635, 1), (640, 1), (645, 0), (650, 0), (655, 0), (660, 0), (665, 1), (670, 1), (675, 1), (680, 1), (685, 1), (690, 1), (695, 1), (700, 1), (705, 1), (710, 0), (715, 1), (720, 1), (725, 1), (730, 1), (735, 1), (740, 1), (745, 1), (750, 1), (755, 1), (760, 0), (765, 0), (770, 0), (775, 0), (780, 0), (785, 1), (790, 1), (795, 0), (800, 0), (805, 0), (810, 0), (815, 0), (820, 0), (825, 0), (830, 0), (835, 0), (840, 0), (845, 0), (850, 0), (855, 0), (860, 1), (865, 0), (870, 0), (875, 0), (880, 0), (885, 0), (890, 1), (895, 1), (900, 0), (905, 0), (910, 1), (915, 1), (920, 1), (925, 1), (930, 1), (935, 1), (940, 1), (945, 1), (950, 1), (955, 1), (960, 1), (965, 1), (970, 1), (975, 1), (980, 1), (985, 1), (990, 1), (995, 0), (1000, 0), (1005, 0), (1010, 0), (1015, 0), (1020, 0), (1025, 0)]
Vdin0_16  din0_16  0 PWL (0n 0.0v 4.745n 0.0v 4.755n 0.0v 9.745n 0.0v 9.755n 1.1v 14.745n 1.1v 14.755n 1.1v 19.745n 1.1v 19.755n 1.1v 24.745n 1.1v 24.755n 1.1v 29.745n 1.1v 29.755n 1.1v 34.745n 1.1v 34.755n 1.1v 39.745n 1.1v 39.755n 1.1v 44.745n 1.1v 44.755n 1.1v 49.745n 1.1v 49.755n 1.1v 54.745n 1.1v 54.755n 1.1v 59.745n 1.1v 59.755n 1.1v 64.745n 1.1v 64.755n 0.0v 69.745n 0.0v 69.755n 0.0v 74.745n 0.0v 74.755n 0.0v 79.745n 0.0v 79.755n 0.0v 84.745n 0.0v 84.755n 0.0v 89.745n 0.0v 89.755n 0.0v 94.745n 0.0v 94.755n 0.0v 99.745n 0.0v 99.755n 0.0v 104.745n 0.0v 104.755n 0.0v 109.745n 0.0v 109.755n 1.1v 114.745n 1.1v 114.755n 0.0v 119.745n 0.0v 119.755n 0.0v 124.745n 0.0v 124.755n 0.0v 129.745n 0.0v 129.755n 1.1v 134.745n 1.1v 134.755n 0.0v 139.745n 0.0v 139.755n 1.1v 144.745n 1.1v 144.755n 1.1v 149.745n 1.1v 149.755n 1.1v 154.745n 1.1v 154.755n 1.1v 159.745n 1.1v 159.755n 1.1v 164.745n 1.1v 164.755n 1.1v 169.745n 1.1v 169.755n 1.1v 174.745n 1.1v 174.755n 1.1v 179.745n 1.1v 179.755n 1.1v 184.745n 1.1v 184.755n 1.1v 189.745n 1.1v 189.755n 1.1v 194.745n 1.1v 194.755n 1.1v 199.745n 1.1v 199.755n 1.1v 204.745n 1.1v 204.755n 1.1v 209.745n 1.1v 209.755n 1.1v 214.745n 1.1v 214.755n 1.1v 219.745n 1.1v 219.755n 1.1v 224.745n 1.1v 224.755n 1.1v 229.745n 1.1v 229.755n 1.1v 234.745n 1.1v 234.755n 1.1v 239.745n 1.1v 239.755n 1.1v 244.745n 1.1v 244.755n 1.1v 249.745n 1.1v 249.755n 1.1v 254.745n 1.1v 254.755n 1.1v 259.745n 1.1v 259.755n 1.1v 264.745n 1.1v 264.755n 1.1v 269.745n 1.1v 269.755n 0.0v 274.745n 0.0v 274.755n 0.0v 279.745n 0.0v 279.755n 0.0v 284.745n 0.0v 284.755n 0.0v 289.745n 0.0v 289.755n 0.0v 294.745n 0.0v 294.755n 0.0v 299.745n 0.0v 299.755n 0.0v 304.745n 0.0v 304.755n 0.0v 309.745n 0.0v 309.755n 0.0v 314.745n 0.0v 314.755n 0.0v 319.745n 0.0v 319.755n 0.0v 324.745n 0.0v 324.755n 0.0v 329.745n 0.0v 329.755n 0.0v 334.745n 0.0v 334.755n 0.0v 339.745n 0.0v 339.755n 0.0v 344.745n 0.0v 344.755n 0.0v 349.745n 0.0v 349.755n 0.0v 354.745n 0.0v 354.755n 1.1v 359.745n 1.1v 359.755n 1.1v 364.745n 1.1v 364.755n 1.1v 369.745n 1.1v 369.755n 1.1v 374.745n 1.1v 374.755n 1.1v 379.745n 1.1v 379.755n 1.1v 384.745n 1.1v 384.755n 1.1v 389.745n 1.1v 389.755n 1.1v 394.745n 1.1v 394.755n 1.1v 399.745n 1.1v 399.755n 1.1v 404.745n 1.1v 404.755n 1.1v 409.745n 1.1v 409.755n 1.1v 414.745n 1.1v 414.755n 1.1v 419.745n 1.1v 419.755n 1.1v 424.745n 1.1v 424.755n 1.1v 429.745n 1.1v 429.755n 1.1v 434.745n 1.1v 434.755n 1.1v 439.745n 1.1v 439.755n 1.1v 444.745n 1.1v 444.755n 1.1v 449.745n 1.1v 449.755n 1.1v 454.745n 1.1v 454.755n 1.1v 459.745n 1.1v 459.755n 1.1v 464.745n 1.1v 464.755n 1.1v 469.745n 1.1v 469.755n 1.1v 474.745n 1.1v 474.755n 1.1v 479.745n 1.1v 479.755n 1.1v 484.745n 1.1v 484.755n 1.1v 489.745n 1.1v 489.755n 1.1v 494.745n 1.1v 494.755n 1.1v 499.745n 1.1v 499.755n 1.1v 504.745n 1.1v 504.755n 1.1v 509.745n 1.1v 509.755n 1.1v 514.745n 1.1v 514.755n 1.1v 519.745n 1.1v 519.755n 0.0v 524.745n 0.0v 524.755n 0.0v 529.745n 0.0v 529.755n 0.0v 534.745n 0.0v 534.755n 0.0v 539.745n 0.0v 539.755n 0.0v 544.745n 0.0v 544.755n 0.0v 549.745n 0.0v 549.755n 0.0v 554.745n 0.0v 554.755n 0.0v 559.745n 0.0v 559.755n 0.0v 564.745n 0.0v 564.755n 0.0v 569.745n 0.0v 569.755n 0.0v 574.745n 0.0v 574.755n 0.0v 579.745n 0.0v 579.755n 0.0v 584.745n 0.0v 584.755n 0.0v 589.745n 0.0v 589.755n 0.0v 594.745n 0.0v 594.755n 0.0v 599.745n 0.0v 599.755n 0.0v 604.745n 0.0v 604.755n 0.0v 609.745n 0.0v 609.755n 0.0v 614.745n 0.0v 614.755n 0.0v 619.745n 0.0v 619.755n 1.1v 624.745n 1.1v 624.755n 1.1v 629.745n 1.1v 629.755n 1.1v 634.745n 1.1v 634.755n 1.1v 639.745n 1.1v 639.755n 1.1v 644.745n 1.1v 644.755n 0.0v 649.745n 0.0v 649.755n 0.0v 654.745n 0.0v 654.755n 0.0v 659.745n 0.0v 659.755n 0.0v 664.745n 0.0v 664.755n 1.1v 669.745n 1.1v 669.755n 1.1v 674.745n 1.1v 674.755n 1.1v 679.745n 1.1v 679.755n 1.1v 684.745n 1.1v 684.755n 1.1v 689.745n 1.1v 689.755n 1.1v 694.745n 1.1v 694.755n 1.1v 699.745n 1.1v 699.755n 1.1v 704.745n 1.1v 704.755n 1.1v 709.745n 1.1v 709.755n 0.0v 714.745n 0.0v 714.755n 1.1v 719.745n 1.1v 719.755n 1.1v 724.745n 1.1v 724.755n 1.1v 729.745n 1.1v 729.755n 1.1v 734.745n 1.1v 734.755n 1.1v 739.745n 1.1v 739.755n 1.1v 744.745n 1.1v 744.755n 1.1v 749.745n 1.1v 749.755n 1.1v 754.745n 1.1v 754.755n 1.1v 759.745n 1.1v 759.755n 0.0v 764.745n 0.0v 764.755n 0.0v 769.745n 0.0v 769.755n 0.0v 774.745n 0.0v 774.755n 0.0v 779.745n 0.0v 779.755n 0.0v 784.745n 0.0v 784.755n 1.1v 789.745n 1.1v 789.755n 1.1v 794.745n 1.1v 794.755n 0.0v 799.745n 0.0v 799.755n 0.0v 804.745n 0.0v 804.755n 0.0v 809.745n 0.0v 809.755n 0.0v 814.745n 0.0v 814.755n 0.0v 819.745n 0.0v 819.755n 0.0v 824.745n 0.0v 824.755n 0.0v 829.745n 0.0v 829.755n 0.0v 834.745n 0.0v 834.755n 0.0v 839.745n 0.0v 839.755n 0.0v 844.745n 0.0v 844.755n 0.0v 849.745n 0.0v 849.755n 0.0v 854.745n 0.0v 854.755n 0.0v 859.745n 0.0v 859.755n 1.1v 864.745n 1.1v 864.755n 0.0v 869.745n 0.0v 869.755n 0.0v 874.745n 0.0v 874.755n 0.0v 879.745n 0.0v 879.755n 0.0v 884.745n 0.0v 884.755n 0.0v 889.745n 0.0v 889.755n 1.1v 894.745n 1.1v 894.755n 1.1v 899.745n 1.1v 899.755n 0.0v 904.745n 0.0v 904.755n 0.0v 909.745n 0.0v 909.755n 1.1v 914.745n 1.1v 914.755n 1.1v 919.745n 1.1v 919.755n 1.1v 924.745n 1.1v 924.755n 1.1v 929.745n 1.1v 929.755n 1.1v 934.745n 1.1v 934.755n 1.1v 939.745n 1.1v 939.755n 1.1v 944.745n 1.1v 944.755n 1.1v 949.745n 1.1v 949.755n 1.1v 954.745n 1.1v 954.755n 1.1v 959.745n 1.1v 959.755n 1.1v 964.745n 1.1v 964.755n 1.1v 969.745n 1.1v 969.755n 1.1v 974.745n 1.1v 974.755n 1.1v 979.745n 1.1v 979.755n 1.1v 984.745n 1.1v 984.755n 1.1v 989.745n 1.1v 989.755n 1.1v 994.745n 1.1v 994.755n 0.0v 999.745n 0.0v 999.755n 0.0v 1004.745n 0.0v 1004.755n 0.0v 1009.745n 0.0v 1009.755n 0.0v 1014.745n 0.0v 1014.755n 0.0v 1019.745n 0.0v 1019.755n 0.0v 1024.745n 0.0v 1024.755n 0.0v )
* (time, data): [(0, 0), (5, 1), (10, 1), (15, 1), (20, 1), (25, 1), (30, 1), (35, 1), (40, 1), (45, 1), (50, 1), (55, 1), (60, 0), (65, 0), (70, 0), (75, 0), (80, 1), (85, 1), (90, 1), (95, 0), (100, 0), (105, 0), (110, 0), (115, 1), (120, 1), (125, 1), (130, 1), (135, 1), (140, 0), (145, 0), (150, 0), (155, 0), (160, 0), (165, 0), (170, 0), (175, 0), (180, 0), (185, 0), (190, 0), (195, 0), (200, 0), (205, 0), (210, 0), (215, 0), (220, 0), (225, 0), (230, 0), (235, 0), (240, 0), (245, 0), (250, 0), (255, 0), (260, 0), (265, 1), (270, 1), (275, 1), (280, 1), (285, 1), (290, 1), (295, 1), (300, 1), (305, 1), (310, 1), (315, 1), (320, 1), (325, 1), (330, 1), (335, 1), (340, 1), (345, 1), (350, 1), (355, 0), (360, 0), (365, 0), (370, 0), (375, 0), (380, 0), (385, 0), (390, 0), (395, 0), (400, 0), (405, 0), (410, 0), (415, 0), (420, 1), (425, 1), (430, 1), (435, 1), (440, 1), (445, 1), (450, 1), (455, 1), (460, 1), (465, 1), (470, 1), (475, 0), (480, 0), (485, 0), (490, 0), (495, 1), (500, 1), (505, 1), (510, 1), (515, 1), (520, 1), (525, 1), (530, 1), (535, 1), (540, 1), (545, 1), (550, 1), (555, 1), (560, 1), (565, 1), (570, 1), (575, 1), (580, 1), (585, 1), (590, 1), (595, 1), (600, 1), (605, 1), (610, 1), (615, 1), (620, 0), (625, 0), (630, 0), (635, 0), (640, 0), (645, 1), (650, 1), (655, 1), (660, 0), (665, 0), (670, 0), (675, 0), (680, 1), (685, 1), (690, 1), (695, 1), (700, 1), (705, 1), (710, 1), (715, 1), (720, 1), (725, 1), (730, 1), (735, 1), (740, 0), (745, 0), (750, 0), (755, 0), (760, 1), (765, 1), (770, 1), (775, 1), (780, 1), (785, 0), (790, 1), (795, 0), (800, 0), (805, 0), (810, 0), (815, 0), (820, 0), (825, 0), (830, 0), (835, 0), (840, 0), (845, 1), (850, 1), (855, 1), (860, 1), (865, 1), (870, 1), (875, 1), (880, 1), (885, 1), (890, 1), (895, 1), (900, 0), (905, 0), (910, 1), (915, 1), (920, 1), (925, 1), (930, 1), (935, 1), (940, 1), (945, 1), (950, 1), (955, 1), (960, 1), (965, 1), (970, 1), (975, 1), (980, 1), (985, 1), (990, 1), (995, 1), (1000, 1), (1005, 0), (1010, 0), (1015, 0), (1020, 0), (1025, 0)]
Vdin0_17  din0_17  0 PWL (0n 0.0v 4.745n 0.0v 4.755n 1.1v 9.745n 1.1v 9.755n 1.1v 14.745n 1.1v 14.755n 1.1v 19.745n 1.1v 19.755n 1.1v 24.745n 1.1v 24.755n 1.1v 29.745n 1.1v 29.755n 1.1v 34.745n 1.1v 34.755n 1.1v 39.745n 1.1v 39.755n 1.1v 44.745n 1.1v 44.755n 1.1v 49.745n 1.1v 49.755n 1.1v 54.745n 1.1v 54.755n 1.1v 59.745n 1.1v 59.755n 0.0v 64.745n 0.0v 64.755n 0.0v 69.745n 0.0v 69.755n 0.0v 74.745n 0.0v 74.755n 0.0v 79.745n 0.0v 79.755n 1.1v 84.745n 1.1v 84.755n 1.1v 89.745n 1.1v 89.755n 1.1v 94.745n 1.1v 94.755n 0.0v 99.745n 0.0v 99.755n 0.0v 104.745n 0.0v 104.755n 0.0v 109.745n 0.0v 109.755n 0.0v 114.745n 0.0v 114.755n 1.1v 119.745n 1.1v 119.755n 1.1v 124.745n 1.1v 124.755n 1.1v 129.745n 1.1v 129.755n 1.1v 134.745n 1.1v 134.755n 1.1v 139.745n 1.1v 139.755n 0.0v 144.745n 0.0v 144.755n 0.0v 149.745n 0.0v 149.755n 0.0v 154.745n 0.0v 154.755n 0.0v 159.745n 0.0v 159.755n 0.0v 164.745n 0.0v 164.755n 0.0v 169.745n 0.0v 169.755n 0.0v 174.745n 0.0v 174.755n 0.0v 179.745n 0.0v 179.755n 0.0v 184.745n 0.0v 184.755n 0.0v 189.745n 0.0v 189.755n 0.0v 194.745n 0.0v 194.755n 0.0v 199.745n 0.0v 199.755n 0.0v 204.745n 0.0v 204.755n 0.0v 209.745n 0.0v 209.755n 0.0v 214.745n 0.0v 214.755n 0.0v 219.745n 0.0v 219.755n 0.0v 224.745n 0.0v 224.755n 0.0v 229.745n 0.0v 229.755n 0.0v 234.745n 0.0v 234.755n 0.0v 239.745n 0.0v 239.755n 0.0v 244.745n 0.0v 244.755n 0.0v 249.745n 0.0v 249.755n 0.0v 254.745n 0.0v 254.755n 0.0v 259.745n 0.0v 259.755n 0.0v 264.745n 0.0v 264.755n 1.1v 269.745n 1.1v 269.755n 1.1v 274.745n 1.1v 274.755n 1.1v 279.745n 1.1v 279.755n 1.1v 284.745n 1.1v 284.755n 1.1v 289.745n 1.1v 289.755n 1.1v 294.745n 1.1v 294.755n 1.1v 299.745n 1.1v 299.755n 1.1v 304.745n 1.1v 304.755n 1.1v 309.745n 1.1v 309.755n 1.1v 314.745n 1.1v 314.755n 1.1v 319.745n 1.1v 319.755n 1.1v 324.745n 1.1v 324.755n 1.1v 329.745n 1.1v 329.755n 1.1v 334.745n 1.1v 334.755n 1.1v 339.745n 1.1v 339.755n 1.1v 344.745n 1.1v 344.755n 1.1v 349.745n 1.1v 349.755n 1.1v 354.745n 1.1v 354.755n 0.0v 359.745n 0.0v 359.755n 0.0v 364.745n 0.0v 364.755n 0.0v 369.745n 0.0v 369.755n 0.0v 374.745n 0.0v 374.755n 0.0v 379.745n 0.0v 379.755n 0.0v 384.745n 0.0v 384.755n 0.0v 389.745n 0.0v 389.755n 0.0v 394.745n 0.0v 394.755n 0.0v 399.745n 0.0v 399.755n 0.0v 404.745n 0.0v 404.755n 0.0v 409.745n 0.0v 409.755n 0.0v 414.745n 0.0v 414.755n 0.0v 419.745n 0.0v 419.755n 1.1v 424.745n 1.1v 424.755n 1.1v 429.745n 1.1v 429.755n 1.1v 434.745n 1.1v 434.755n 1.1v 439.745n 1.1v 439.755n 1.1v 444.745n 1.1v 444.755n 1.1v 449.745n 1.1v 449.755n 1.1v 454.745n 1.1v 454.755n 1.1v 459.745n 1.1v 459.755n 1.1v 464.745n 1.1v 464.755n 1.1v 469.745n 1.1v 469.755n 1.1v 474.745n 1.1v 474.755n 0.0v 479.745n 0.0v 479.755n 0.0v 484.745n 0.0v 484.755n 0.0v 489.745n 0.0v 489.755n 0.0v 494.745n 0.0v 494.755n 1.1v 499.745n 1.1v 499.755n 1.1v 504.745n 1.1v 504.755n 1.1v 509.745n 1.1v 509.755n 1.1v 514.745n 1.1v 514.755n 1.1v 519.745n 1.1v 519.755n 1.1v 524.745n 1.1v 524.755n 1.1v 529.745n 1.1v 529.755n 1.1v 534.745n 1.1v 534.755n 1.1v 539.745n 1.1v 539.755n 1.1v 544.745n 1.1v 544.755n 1.1v 549.745n 1.1v 549.755n 1.1v 554.745n 1.1v 554.755n 1.1v 559.745n 1.1v 559.755n 1.1v 564.745n 1.1v 564.755n 1.1v 569.745n 1.1v 569.755n 1.1v 574.745n 1.1v 574.755n 1.1v 579.745n 1.1v 579.755n 1.1v 584.745n 1.1v 584.755n 1.1v 589.745n 1.1v 589.755n 1.1v 594.745n 1.1v 594.755n 1.1v 599.745n 1.1v 599.755n 1.1v 604.745n 1.1v 604.755n 1.1v 609.745n 1.1v 609.755n 1.1v 614.745n 1.1v 614.755n 1.1v 619.745n 1.1v 619.755n 0.0v 624.745n 0.0v 624.755n 0.0v 629.745n 0.0v 629.755n 0.0v 634.745n 0.0v 634.755n 0.0v 639.745n 0.0v 639.755n 0.0v 644.745n 0.0v 644.755n 1.1v 649.745n 1.1v 649.755n 1.1v 654.745n 1.1v 654.755n 1.1v 659.745n 1.1v 659.755n 0.0v 664.745n 0.0v 664.755n 0.0v 669.745n 0.0v 669.755n 0.0v 674.745n 0.0v 674.755n 0.0v 679.745n 0.0v 679.755n 1.1v 684.745n 1.1v 684.755n 1.1v 689.745n 1.1v 689.755n 1.1v 694.745n 1.1v 694.755n 1.1v 699.745n 1.1v 699.755n 1.1v 704.745n 1.1v 704.755n 1.1v 709.745n 1.1v 709.755n 1.1v 714.745n 1.1v 714.755n 1.1v 719.745n 1.1v 719.755n 1.1v 724.745n 1.1v 724.755n 1.1v 729.745n 1.1v 729.755n 1.1v 734.745n 1.1v 734.755n 1.1v 739.745n 1.1v 739.755n 0.0v 744.745n 0.0v 744.755n 0.0v 749.745n 0.0v 749.755n 0.0v 754.745n 0.0v 754.755n 0.0v 759.745n 0.0v 759.755n 1.1v 764.745n 1.1v 764.755n 1.1v 769.745n 1.1v 769.755n 1.1v 774.745n 1.1v 774.755n 1.1v 779.745n 1.1v 779.755n 1.1v 784.745n 1.1v 784.755n 0.0v 789.745n 0.0v 789.755n 1.1v 794.745n 1.1v 794.755n 0.0v 799.745n 0.0v 799.755n 0.0v 804.745n 0.0v 804.755n 0.0v 809.745n 0.0v 809.755n 0.0v 814.745n 0.0v 814.755n 0.0v 819.745n 0.0v 819.755n 0.0v 824.745n 0.0v 824.755n 0.0v 829.745n 0.0v 829.755n 0.0v 834.745n 0.0v 834.755n 0.0v 839.745n 0.0v 839.755n 0.0v 844.745n 0.0v 844.755n 1.1v 849.745n 1.1v 849.755n 1.1v 854.745n 1.1v 854.755n 1.1v 859.745n 1.1v 859.755n 1.1v 864.745n 1.1v 864.755n 1.1v 869.745n 1.1v 869.755n 1.1v 874.745n 1.1v 874.755n 1.1v 879.745n 1.1v 879.755n 1.1v 884.745n 1.1v 884.755n 1.1v 889.745n 1.1v 889.755n 1.1v 894.745n 1.1v 894.755n 1.1v 899.745n 1.1v 899.755n 0.0v 904.745n 0.0v 904.755n 0.0v 909.745n 0.0v 909.755n 1.1v 914.745n 1.1v 914.755n 1.1v 919.745n 1.1v 919.755n 1.1v 924.745n 1.1v 924.755n 1.1v 929.745n 1.1v 929.755n 1.1v 934.745n 1.1v 934.755n 1.1v 939.745n 1.1v 939.755n 1.1v 944.745n 1.1v 944.755n 1.1v 949.745n 1.1v 949.755n 1.1v 954.745n 1.1v 954.755n 1.1v 959.745n 1.1v 959.755n 1.1v 964.745n 1.1v 964.755n 1.1v 969.745n 1.1v 969.755n 1.1v 974.745n 1.1v 974.755n 1.1v 979.745n 1.1v 979.755n 1.1v 984.745n 1.1v 984.755n 1.1v 989.745n 1.1v 989.755n 1.1v 994.745n 1.1v 994.755n 1.1v 999.745n 1.1v 999.755n 1.1v 1004.745n 1.1v 1004.755n 0.0v 1009.745n 0.0v 1009.755n 0.0v 1014.745n 0.0v 1014.755n 0.0v 1019.745n 0.0v 1019.755n 0.0v 1024.745n 0.0v 1024.755n 0.0v )
* (time, data): [(0, 0), (5, 1), (10, 0), (15, 1), (20, 1), (25, 1), (30, 0), (35, 1), (40, 1), (45, 1), (50, 1), (55, 1), (60, 1), (65, 0), (70, 0), (75, 0), (80, 0), (85, 0), (90, 0), (95, 1), (100, 1), (105, 1), (110, 1), (115, 1), (120, 1), (125, 1), (130, 0), (135, 0), (140, 0), (145, 0), (150, 0), (155, 1), (160, 1), (165, 1), (170, 1), (175, 1), (180, 1), (185, 1), (190, 1), (195, 1), (200, 1), (205, 1), (210, 1), (215, 1), (220, 1), (225, 0), (230, 0), (235, 0), (240, 0), (245, 0), (250, 0), (255, 0), (260, 0), (265, 0), (270, 0), (275, 0), (280, 0), (285, 0), (290, 0), (295, 0), (300, 0), (305, 0), (310, 0), (315, 0), (320, 0), (325, 0), (330, 0), (335, 0), (340, 0), (345, 0), (350, 0), (355, 1), (360, 1), (365, 1), (370, 1), (375, 1), (380, 0), (385, 0), (390, 0), (395, 0), (400, 0), (405, 0), (410, 0), (415, 0), (420, 0), (425, 0), (430, 0), (435, 0), (440, 0), (445, 0), (450, 0), (455, 0), (460, 0), (465, 0), (470, 1), (475, 0), (480, 0), (485, 0), (490, 0), (495, 1), (500, 1), (505, 1), (510, 1), (515, 1), (520, 0), (525, 1), (530, 1), (535, 1), (540, 1), (545, 1), (550, 1), (555, 1), (560, 1), (565, 1), (570, 1), (575, 1), (580, 1), (585, 1), (590, 1), (595, 1), (600, 1), (605, 1), (610, 1), (615, 1), (620, 1), (625, 1), (630, 1), (635, 1), (640, 1), (645, 1), (650, 1), (655, 1), (660, 1), (665, 1), (670, 1), (675, 1), (680, 0), (685, 0), (690, 0), (695, 0), (700, 0), (705, 0), (710, 1), (715, 1), (720, 1), (725, 1), (730, 1), (735, 1), (740, 1), (745, 1), (750, 1), (755, 1), (760, 0), (765, 0), (770, 1), (775, 1), (780, 1), (785, 0), (790, 1), (795, 0), (800, 0), (805, 0), (810, 0), (815, 0), (820, 0), (825, 0), (830, 0), (835, 0), (840, 0), (845, 1), (850, 1), (855, 1), (860, 0), (865, 1), (870, 1), (875, 0), (880, 0), (885, 0), (890, 1), (895, 1), (900, 0), (905, 0), (910, 0), (915, 0), (920, 0), (925, 0), (930, 0), (935, 0), (940, 0), (945, 0), (950, 0), (955, 0), (960, 0), (965, 0), (970, 0), (975, 0), (980, 0), (985, 0), (990, 0), (995, 0), (1000, 0), (1005, 0), (1010, 0), (1015, 0), (1020, 0), (1025, 0)]
Vdin0_18  din0_18  0 PWL (0n 0.0v 4.745n 0.0v 4.755n 1.1v 9.745n 1.1v 9.755n 0.0v 14.745n 0.0v 14.755n 1.1v 19.745n 1.1v 19.755n 1.1v 24.745n 1.1v 24.755n 1.1v 29.745n 1.1v 29.755n 0.0v 34.745n 0.0v 34.755n 1.1v 39.745n 1.1v 39.755n 1.1v 44.745n 1.1v 44.755n 1.1v 49.745n 1.1v 49.755n 1.1v 54.745n 1.1v 54.755n 1.1v 59.745n 1.1v 59.755n 1.1v 64.745n 1.1v 64.755n 0.0v 69.745n 0.0v 69.755n 0.0v 74.745n 0.0v 74.755n 0.0v 79.745n 0.0v 79.755n 0.0v 84.745n 0.0v 84.755n 0.0v 89.745n 0.0v 89.755n 0.0v 94.745n 0.0v 94.755n 1.1v 99.745n 1.1v 99.755n 1.1v 104.745n 1.1v 104.755n 1.1v 109.745n 1.1v 109.755n 1.1v 114.745n 1.1v 114.755n 1.1v 119.745n 1.1v 119.755n 1.1v 124.745n 1.1v 124.755n 1.1v 129.745n 1.1v 129.755n 0.0v 134.745n 0.0v 134.755n 0.0v 139.745n 0.0v 139.755n 0.0v 144.745n 0.0v 144.755n 0.0v 149.745n 0.0v 149.755n 0.0v 154.745n 0.0v 154.755n 1.1v 159.745n 1.1v 159.755n 1.1v 164.745n 1.1v 164.755n 1.1v 169.745n 1.1v 169.755n 1.1v 174.745n 1.1v 174.755n 1.1v 179.745n 1.1v 179.755n 1.1v 184.745n 1.1v 184.755n 1.1v 189.745n 1.1v 189.755n 1.1v 194.745n 1.1v 194.755n 1.1v 199.745n 1.1v 199.755n 1.1v 204.745n 1.1v 204.755n 1.1v 209.745n 1.1v 209.755n 1.1v 214.745n 1.1v 214.755n 1.1v 219.745n 1.1v 219.755n 1.1v 224.745n 1.1v 224.755n 0.0v 229.745n 0.0v 229.755n 0.0v 234.745n 0.0v 234.755n 0.0v 239.745n 0.0v 239.755n 0.0v 244.745n 0.0v 244.755n 0.0v 249.745n 0.0v 249.755n 0.0v 254.745n 0.0v 254.755n 0.0v 259.745n 0.0v 259.755n 0.0v 264.745n 0.0v 264.755n 0.0v 269.745n 0.0v 269.755n 0.0v 274.745n 0.0v 274.755n 0.0v 279.745n 0.0v 279.755n 0.0v 284.745n 0.0v 284.755n 0.0v 289.745n 0.0v 289.755n 0.0v 294.745n 0.0v 294.755n 0.0v 299.745n 0.0v 299.755n 0.0v 304.745n 0.0v 304.755n 0.0v 309.745n 0.0v 309.755n 0.0v 314.745n 0.0v 314.755n 0.0v 319.745n 0.0v 319.755n 0.0v 324.745n 0.0v 324.755n 0.0v 329.745n 0.0v 329.755n 0.0v 334.745n 0.0v 334.755n 0.0v 339.745n 0.0v 339.755n 0.0v 344.745n 0.0v 344.755n 0.0v 349.745n 0.0v 349.755n 0.0v 354.745n 0.0v 354.755n 1.1v 359.745n 1.1v 359.755n 1.1v 364.745n 1.1v 364.755n 1.1v 369.745n 1.1v 369.755n 1.1v 374.745n 1.1v 374.755n 1.1v 379.745n 1.1v 379.755n 0.0v 384.745n 0.0v 384.755n 0.0v 389.745n 0.0v 389.755n 0.0v 394.745n 0.0v 394.755n 0.0v 399.745n 0.0v 399.755n 0.0v 404.745n 0.0v 404.755n 0.0v 409.745n 0.0v 409.755n 0.0v 414.745n 0.0v 414.755n 0.0v 419.745n 0.0v 419.755n 0.0v 424.745n 0.0v 424.755n 0.0v 429.745n 0.0v 429.755n 0.0v 434.745n 0.0v 434.755n 0.0v 439.745n 0.0v 439.755n 0.0v 444.745n 0.0v 444.755n 0.0v 449.745n 0.0v 449.755n 0.0v 454.745n 0.0v 454.755n 0.0v 459.745n 0.0v 459.755n 0.0v 464.745n 0.0v 464.755n 0.0v 469.745n 0.0v 469.755n 1.1v 474.745n 1.1v 474.755n 0.0v 479.745n 0.0v 479.755n 0.0v 484.745n 0.0v 484.755n 0.0v 489.745n 0.0v 489.755n 0.0v 494.745n 0.0v 494.755n 1.1v 499.745n 1.1v 499.755n 1.1v 504.745n 1.1v 504.755n 1.1v 509.745n 1.1v 509.755n 1.1v 514.745n 1.1v 514.755n 1.1v 519.745n 1.1v 519.755n 0.0v 524.745n 0.0v 524.755n 1.1v 529.745n 1.1v 529.755n 1.1v 534.745n 1.1v 534.755n 1.1v 539.745n 1.1v 539.755n 1.1v 544.745n 1.1v 544.755n 1.1v 549.745n 1.1v 549.755n 1.1v 554.745n 1.1v 554.755n 1.1v 559.745n 1.1v 559.755n 1.1v 564.745n 1.1v 564.755n 1.1v 569.745n 1.1v 569.755n 1.1v 574.745n 1.1v 574.755n 1.1v 579.745n 1.1v 579.755n 1.1v 584.745n 1.1v 584.755n 1.1v 589.745n 1.1v 589.755n 1.1v 594.745n 1.1v 594.755n 1.1v 599.745n 1.1v 599.755n 1.1v 604.745n 1.1v 604.755n 1.1v 609.745n 1.1v 609.755n 1.1v 614.745n 1.1v 614.755n 1.1v 619.745n 1.1v 619.755n 1.1v 624.745n 1.1v 624.755n 1.1v 629.745n 1.1v 629.755n 1.1v 634.745n 1.1v 634.755n 1.1v 639.745n 1.1v 639.755n 1.1v 644.745n 1.1v 644.755n 1.1v 649.745n 1.1v 649.755n 1.1v 654.745n 1.1v 654.755n 1.1v 659.745n 1.1v 659.755n 1.1v 664.745n 1.1v 664.755n 1.1v 669.745n 1.1v 669.755n 1.1v 674.745n 1.1v 674.755n 1.1v 679.745n 1.1v 679.755n 0.0v 684.745n 0.0v 684.755n 0.0v 689.745n 0.0v 689.755n 0.0v 694.745n 0.0v 694.755n 0.0v 699.745n 0.0v 699.755n 0.0v 704.745n 0.0v 704.755n 0.0v 709.745n 0.0v 709.755n 1.1v 714.745n 1.1v 714.755n 1.1v 719.745n 1.1v 719.755n 1.1v 724.745n 1.1v 724.755n 1.1v 729.745n 1.1v 729.755n 1.1v 734.745n 1.1v 734.755n 1.1v 739.745n 1.1v 739.755n 1.1v 744.745n 1.1v 744.755n 1.1v 749.745n 1.1v 749.755n 1.1v 754.745n 1.1v 754.755n 1.1v 759.745n 1.1v 759.755n 0.0v 764.745n 0.0v 764.755n 0.0v 769.745n 0.0v 769.755n 1.1v 774.745n 1.1v 774.755n 1.1v 779.745n 1.1v 779.755n 1.1v 784.745n 1.1v 784.755n 0.0v 789.745n 0.0v 789.755n 1.1v 794.745n 1.1v 794.755n 0.0v 799.745n 0.0v 799.755n 0.0v 804.745n 0.0v 804.755n 0.0v 809.745n 0.0v 809.755n 0.0v 814.745n 0.0v 814.755n 0.0v 819.745n 0.0v 819.755n 0.0v 824.745n 0.0v 824.755n 0.0v 829.745n 0.0v 829.755n 0.0v 834.745n 0.0v 834.755n 0.0v 839.745n 0.0v 839.755n 0.0v 844.745n 0.0v 844.755n 1.1v 849.745n 1.1v 849.755n 1.1v 854.745n 1.1v 854.755n 1.1v 859.745n 1.1v 859.755n 0.0v 864.745n 0.0v 864.755n 1.1v 869.745n 1.1v 869.755n 1.1v 874.745n 1.1v 874.755n 0.0v 879.745n 0.0v 879.755n 0.0v 884.745n 0.0v 884.755n 0.0v 889.745n 0.0v 889.755n 1.1v 894.745n 1.1v 894.755n 1.1v 899.745n 1.1v 899.755n 0.0v 904.745n 0.0v 904.755n 0.0v 909.745n 0.0v 909.755n 0.0v 914.745n 0.0v 914.755n 0.0v 919.745n 0.0v 919.755n 0.0v 924.745n 0.0v 924.755n 0.0v 929.745n 0.0v 929.755n 0.0v 934.745n 0.0v 934.755n 0.0v 939.745n 0.0v 939.755n 0.0v 944.745n 0.0v 944.755n 0.0v 949.745n 0.0v 949.755n 0.0v 954.745n 0.0v 954.755n 0.0v 959.745n 0.0v 959.755n 0.0v 964.745n 0.0v 964.755n 0.0v 969.745n 0.0v 969.755n 0.0v 974.745n 0.0v 974.755n 0.0v 979.745n 0.0v 979.755n 0.0v 984.745n 0.0v 984.755n 0.0v 989.745n 0.0v 989.755n 0.0v 994.745n 0.0v 994.755n 0.0v 999.745n 0.0v 999.755n 0.0v 1004.745n 0.0v 1004.755n 0.0v 1009.745n 0.0v 1009.755n 0.0v 1014.745n 0.0v 1014.755n 0.0v 1019.745n 0.0v 1019.755n 0.0v 1024.745n 0.0v 1024.755n 0.0v )
* (time, data): [(0, 0), (5, 0), (10, 0), (15, 0), (20, 0), (25, 0), (30, 1), (35, 0), (40, 0), (45, 0), (50, 0), (55, 0), (60, 1), (65, 1), (70, 1), (75, 1), (80, 1), (85, 1), (90, 1), (95, 0), (100, 0), (105, 0), (110, 1), (115, 1), (120, 1), (125, 1), (130, 1), (135, 1), (140, 0), (145, 0), (150, 1), (155, 0), (160, 0), (165, 0), (170, 0), (175, 0), (180, 0), (185, 0), (190, 0), (195, 0), (200, 0), (205, 0), (210, 0), (215, 0), (220, 0), (225, 1), (230, 1), (235, 1), (240, 1), (245, 1), (250, 1), (255, 1), (260, 1), (265, 1), (270, 0), (275, 0), (280, 0), (285, 0), (290, 0), (295, 0), (300, 0), (305, 0), (310, 0), (315, 0), (320, 0), (325, 0), (330, 0), (335, 0), (340, 0), (345, 0), (350, 0), (355, 1), (360, 1), (365, 1), (370, 1), (375, 1), (380, 0), (385, 0), (390, 0), (395, 0), (400, 0), (405, 0), (410, 0), (415, 0), (420, 1), (425, 1), (430, 1), (435, 1), (440, 1), (445, 1), (450, 1), (455, 1), (460, 1), (465, 1), (470, 1), (475, 1), (480, 1), (485, 1), (490, 1), (495, 0), (500, 0), (505, 0), (510, 0), (515, 0), (520, 0), (525, 0), (530, 0), (535, 1), (540, 1), (545, 1), (550, 1), (555, 1), (560, 1), (565, 1), (570, 1), (575, 1), (580, 1), (585, 1), (590, 1), (595, 1), (600, 1), (605, 1), (610, 1), (615, 1), (620, 1), (625, 1), (630, 1), (635, 1), (640, 1), (645, 0), (650, 0), (655, 0), (660, 1), (665, 1), (670, 1), (675, 1), (680, 0), (685, 0), (690, 0), (695, 0), (700, 0), (705, 0), (710, 1), (715, 1), (720, 1), (725, 1), (730, 1), (735, 1), (740, 1), (745, 1), (750, 1), (755, 1), (760, 1), (765, 1), (770, 0), (775, 0), (780, 0), (785, 1), (790, 1), (795, 1), (800, 1), (805, 1), (810, 1), (815, 1), (820, 1), (825, 1), (830, 1), (835, 1), (840, 1), (845, 0), (850, 0), (855, 0), (860, 1), (865, 0), (870, 0), (875, 0), (880, 0), (885, 0), (890, 1), (895, 1), (900, 0), (905, 0), (910, 0), (915, 0), (920, 0), (925, 0), (930, 0), (935, 0), (940, 0), (945, 0), (950, 0), (955, 0), (960, 0), (965, 0), (970, 0), (975, 0), (980, 0), (985, 0), (990, 0), (995, 1), (1000, 1), (1005, 1), (1010, 1), (1015, 1), (1020, 1), (1025, 1)]
Vdin0_19  din0_19  0 PWL (0n 0.0v 4.745n 0.0v 4.755n 0.0v 9.745n 0.0v 9.755n 0.0v 14.745n 0.0v 14.755n 0.0v 19.745n 0.0v 19.755n 0.0v 24.745n 0.0v 24.755n 0.0v 29.745n 0.0v 29.755n 1.1v 34.745n 1.1v 34.755n 0.0v 39.745n 0.0v 39.755n 0.0v 44.745n 0.0v 44.755n 0.0v 49.745n 0.0v 49.755n 0.0v 54.745n 0.0v 54.755n 0.0v 59.745n 0.0v 59.755n 1.1v 64.745n 1.1v 64.755n 1.1v 69.745n 1.1v 69.755n 1.1v 74.745n 1.1v 74.755n 1.1v 79.745n 1.1v 79.755n 1.1v 84.745n 1.1v 84.755n 1.1v 89.745n 1.1v 89.755n 1.1v 94.745n 1.1v 94.755n 0.0v 99.745n 0.0v 99.755n 0.0v 104.745n 0.0v 104.755n 0.0v 109.745n 0.0v 109.755n 1.1v 114.745n 1.1v 114.755n 1.1v 119.745n 1.1v 119.755n 1.1v 124.745n 1.1v 124.755n 1.1v 129.745n 1.1v 129.755n 1.1v 134.745n 1.1v 134.755n 1.1v 139.745n 1.1v 139.755n 0.0v 144.745n 0.0v 144.755n 0.0v 149.745n 0.0v 149.755n 1.1v 154.745n 1.1v 154.755n 0.0v 159.745n 0.0v 159.755n 0.0v 164.745n 0.0v 164.755n 0.0v 169.745n 0.0v 169.755n 0.0v 174.745n 0.0v 174.755n 0.0v 179.745n 0.0v 179.755n 0.0v 184.745n 0.0v 184.755n 0.0v 189.745n 0.0v 189.755n 0.0v 194.745n 0.0v 194.755n 0.0v 199.745n 0.0v 199.755n 0.0v 204.745n 0.0v 204.755n 0.0v 209.745n 0.0v 209.755n 0.0v 214.745n 0.0v 214.755n 0.0v 219.745n 0.0v 219.755n 0.0v 224.745n 0.0v 224.755n 1.1v 229.745n 1.1v 229.755n 1.1v 234.745n 1.1v 234.755n 1.1v 239.745n 1.1v 239.755n 1.1v 244.745n 1.1v 244.755n 1.1v 249.745n 1.1v 249.755n 1.1v 254.745n 1.1v 254.755n 1.1v 259.745n 1.1v 259.755n 1.1v 264.745n 1.1v 264.755n 1.1v 269.745n 1.1v 269.755n 0.0v 274.745n 0.0v 274.755n 0.0v 279.745n 0.0v 279.755n 0.0v 284.745n 0.0v 284.755n 0.0v 289.745n 0.0v 289.755n 0.0v 294.745n 0.0v 294.755n 0.0v 299.745n 0.0v 299.755n 0.0v 304.745n 0.0v 304.755n 0.0v 309.745n 0.0v 309.755n 0.0v 314.745n 0.0v 314.755n 0.0v 319.745n 0.0v 319.755n 0.0v 324.745n 0.0v 324.755n 0.0v 329.745n 0.0v 329.755n 0.0v 334.745n 0.0v 334.755n 0.0v 339.745n 0.0v 339.755n 0.0v 344.745n 0.0v 344.755n 0.0v 349.745n 0.0v 349.755n 0.0v 354.745n 0.0v 354.755n 1.1v 359.745n 1.1v 359.755n 1.1v 364.745n 1.1v 364.755n 1.1v 369.745n 1.1v 369.755n 1.1v 374.745n 1.1v 374.755n 1.1v 379.745n 1.1v 379.755n 0.0v 384.745n 0.0v 384.755n 0.0v 389.745n 0.0v 389.755n 0.0v 394.745n 0.0v 394.755n 0.0v 399.745n 0.0v 399.755n 0.0v 404.745n 0.0v 404.755n 0.0v 409.745n 0.0v 409.755n 0.0v 414.745n 0.0v 414.755n 0.0v 419.745n 0.0v 419.755n 1.1v 424.745n 1.1v 424.755n 1.1v 429.745n 1.1v 429.755n 1.1v 434.745n 1.1v 434.755n 1.1v 439.745n 1.1v 439.755n 1.1v 444.745n 1.1v 444.755n 1.1v 449.745n 1.1v 449.755n 1.1v 454.745n 1.1v 454.755n 1.1v 459.745n 1.1v 459.755n 1.1v 464.745n 1.1v 464.755n 1.1v 469.745n 1.1v 469.755n 1.1v 474.745n 1.1v 474.755n 1.1v 479.745n 1.1v 479.755n 1.1v 484.745n 1.1v 484.755n 1.1v 489.745n 1.1v 489.755n 1.1v 494.745n 1.1v 494.755n 0.0v 499.745n 0.0v 499.755n 0.0v 504.745n 0.0v 504.755n 0.0v 509.745n 0.0v 509.755n 0.0v 514.745n 0.0v 514.755n 0.0v 519.745n 0.0v 519.755n 0.0v 524.745n 0.0v 524.755n 0.0v 529.745n 0.0v 529.755n 0.0v 534.745n 0.0v 534.755n 1.1v 539.745n 1.1v 539.755n 1.1v 544.745n 1.1v 544.755n 1.1v 549.745n 1.1v 549.755n 1.1v 554.745n 1.1v 554.755n 1.1v 559.745n 1.1v 559.755n 1.1v 564.745n 1.1v 564.755n 1.1v 569.745n 1.1v 569.755n 1.1v 574.745n 1.1v 574.755n 1.1v 579.745n 1.1v 579.755n 1.1v 584.745n 1.1v 584.755n 1.1v 589.745n 1.1v 589.755n 1.1v 594.745n 1.1v 594.755n 1.1v 599.745n 1.1v 599.755n 1.1v 604.745n 1.1v 604.755n 1.1v 609.745n 1.1v 609.755n 1.1v 614.745n 1.1v 614.755n 1.1v 619.745n 1.1v 619.755n 1.1v 624.745n 1.1v 624.755n 1.1v 629.745n 1.1v 629.755n 1.1v 634.745n 1.1v 634.755n 1.1v 639.745n 1.1v 639.755n 1.1v 644.745n 1.1v 644.755n 0.0v 649.745n 0.0v 649.755n 0.0v 654.745n 0.0v 654.755n 0.0v 659.745n 0.0v 659.755n 1.1v 664.745n 1.1v 664.755n 1.1v 669.745n 1.1v 669.755n 1.1v 674.745n 1.1v 674.755n 1.1v 679.745n 1.1v 679.755n 0.0v 684.745n 0.0v 684.755n 0.0v 689.745n 0.0v 689.755n 0.0v 694.745n 0.0v 694.755n 0.0v 699.745n 0.0v 699.755n 0.0v 704.745n 0.0v 704.755n 0.0v 709.745n 0.0v 709.755n 1.1v 714.745n 1.1v 714.755n 1.1v 719.745n 1.1v 719.755n 1.1v 724.745n 1.1v 724.755n 1.1v 729.745n 1.1v 729.755n 1.1v 734.745n 1.1v 734.755n 1.1v 739.745n 1.1v 739.755n 1.1v 744.745n 1.1v 744.755n 1.1v 749.745n 1.1v 749.755n 1.1v 754.745n 1.1v 754.755n 1.1v 759.745n 1.1v 759.755n 1.1v 764.745n 1.1v 764.755n 1.1v 769.745n 1.1v 769.755n 0.0v 774.745n 0.0v 774.755n 0.0v 779.745n 0.0v 779.755n 0.0v 784.745n 0.0v 784.755n 1.1v 789.745n 1.1v 789.755n 1.1v 794.745n 1.1v 794.755n 1.1v 799.745n 1.1v 799.755n 1.1v 804.745n 1.1v 804.755n 1.1v 809.745n 1.1v 809.755n 1.1v 814.745n 1.1v 814.755n 1.1v 819.745n 1.1v 819.755n 1.1v 824.745n 1.1v 824.755n 1.1v 829.745n 1.1v 829.755n 1.1v 834.745n 1.1v 834.755n 1.1v 839.745n 1.1v 839.755n 1.1v 844.745n 1.1v 844.755n 0.0v 849.745n 0.0v 849.755n 0.0v 854.745n 0.0v 854.755n 0.0v 859.745n 0.0v 859.755n 1.1v 864.745n 1.1v 864.755n 0.0v 869.745n 0.0v 869.755n 0.0v 874.745n 0.0v 874.755n 0.0v 879.745n 0.0v 879.755n 0.0v 884.745n 0.0v 884.755n 0.0v 889.745n 0.0v 889.755n 1.1v 894.745n 1.1v 894.755n 1.1v 899.745n 1.1v 899.755n 0.0v 904.745n 0.0v 904.755n 0.0v 909.745n 0.0v 909.755n 0.0v 914.745n 0.0v 914.755n 0.0v 919.745n 0.0v 919.755n 0.0v 924.745n 0.0v 924.755n 0.0v 929.745n 0.0v 929.755n 0.0v 934.745n 0.0v 934.755n 0.0v 939.745n 0.0v 939.755n 0.0v 944.745n 0.0v 944.755n 0.0v 949.745n 0.0v 949.755n 0.0v 954.745n 0.0v 954.755n 0.0v 959.745n 0.0v 959.755n 0.0v 964.745n 0.0v 964.755n 0.0v 969.745n 0.0v 969.755n 0.0v 974.745n 0.0v 974.755n 0.0v 979.745n 0.0v 979.755n 0.0v 984.745n 0.0v 984.755n 0.0v 989.745n 0.0v 989.755n 0.0v 994.745n 0.0v 994.755n 1.1v 999.745n 1.1v 999.755n 1.1v 1004.745n 1.1v 1004.755n 1.1v 1009.745n 1.1v 1009.755n 1.1v 1014.745n 1.1v 1014.755n 1.1v 1019.745n 1.1v 1019.755n 1.1v 1024.745n 1.1v 1024.755n 1.1v )
* (time, data): [(0, 0), (5, 1), (10, 1), (15, 1), (20, 1), (25, 1), (30, 0), (35, 1), (40, 1), (45, 1), (50, 1), (55, 1), (60, 0), (65, 0), (70, 0), (75, 0), (80, 0), (85, 0), (90, 0), (95, 0), (100, 0), (105, 0), (110, 0), (115, 0), (120, 0), (125, 0), (130, 1), (135, 1), (140, 1), (145, 1), (150, 0), (155, 0), (160, 0), (165, 0), (170, 0), (175, 0), (180, 0), (185, 0), (190, 0), (195, 0), (200, 0), (205, 0), (210, 0), (215, 0), (220, 0), (225, 1), (230, 1), (235, 1), (240, 1), (245, 1), (250, 1), (255, 1), (260, 1), (265, 1), (270, 1), (275, 1), (280, 1), (285, 1), (290, 1), (295, 1), (300, 1), (305, 1), (310, 1), (315, 1), (320, 1), (325, 1), (330, 1), (335, 1), (340, 1), (345, 1), (350, 1), (355, 0), (360, 0), (365, 0), (370, 0), (375, 0), (380, 0), (385, 0), (390, 0), (395, 0), (400, 0), (405, 0), (410, 0), (415, 0), (420, 1), (425, 1), (430, 1), (435, 1), (440, 1), (445, 1), (450, 1), (455, 1), (460, 1), (465, 1), (470, 1), (475, 0), (480, 0), (485, 0), (490, 0), (495, 0), (500, 0), (505, 0), (510, 0), (515, 0), (520, 1), (525, 1), (530, 1), (535, 1), (540, 1), (545, 1), (550, 1), (555, 1), (560, 1), (565, 1), (570, 1), (575, 1), (580, 1), (585, 1), (590, 1), (595, 1), (600, 1), (605, 1), (610, 1), (615, 1), (620, 0), (625, 0), (630, 0), (635, 0), (640, 0), (645, 0), (650, 0), (655, 0), (660, 1), (665, 1), (670, 1), (675, 0), (680, 0), (685, 0), (690, 0), (695, 0), (700, 0), (705, 0), (710, 0), (715, 1), (720, 1), (725, 1), (730, 1), (735, 1), (740, 0), (745, 0), (750, 0), (755, 0), (760, 0), (765, 0), (770, 1), (775, 1), (780, 1), (785, 0), (790, 0), (795, 0), (800, 0), (805, 0), (810, 0), (815, 0), (820, 0), (825, 0), (830, 0), (835, 0), (840, 0), (845, 0), (850, 0), (855, 0), (860, 1), (865, 1), (870, 1), (875, 1), (880, 1), (885, 1), (890, 0), (895, 0), (900, 1), (905, 1), (910, 1), (915, 1), (920, 1), (925, 1), (930, 1), (935, 1), (940, 1), (945, 1), (950, 1), (955, 1), (960, 1), (965, 1), (970, 1), (975, 0), (980, 0), (985, 0), (990, 0), (995, 0), (1000, 0), (1005, 0), (1010, 0), (1015, 0), (1020, 0), (1025, 0)]
Vdin0_20  din0_20  0 PWL (0n 0.0v 4.745n 0.0v 4.755n 1.1v 9.745n 1.1v 9.755n 1.1v 14.745n 1.1v 14.755n 1.1v 19.745n 1.1v 19.755n 1.1v 24.745n 1.1v 24.755n 1.1v 29.745n 1.1v 29.755n 0.0v 34.745n 0.0v 34.755n 1.1v 39.745n 1.1v 39.755n 1.1v 44.745n 1.1v 44.755n 1.1v 49.745n 1.1v 49.755n 1.1v 54.745n 1.1v 54.755n 1.1v 59.745n 1.1v 59.755n 0.0v 64.745n 0.0v 64.755n 0.0v 69.745n 0.0v 69.755n 0.0v 74.745n 0.0v 74.755n 0.0v 79.745n 0.0v 79.755n 0.0v 84.745n 0.0v 84.755n 0.0v 89.745n 0.0v 89.755n 0.0v 94.745n 0.0v 94.755n 0.0v 99.745n 0.0v 99.755n 0.0v 104.745n 0.0v 104.755n 0.0v 109.745n 0.0v 109.755n 0.0v 114.745n 0.0v 114.755n 0.0v 119.745n 0.0v 119.755n 0.0v 124.745n 0.0v 124.755n 0.0v 129.745n 0.0v 129.755n 1.1v 134.745n 1.1v 134.755n 1.1v 139.745n 1.1v 139.755n 1.1v 144.745n 1.1v 144.755n 1.1v 149.745n 1.1v 149.755n 0.0v 154.745n 0.0v 154.755n 0.0v 159.745n 0.0v 159.755n 0.0v 164.745n 0.0v 164.755n 0.0v 169.745n 0.0v 169.755n 0.0v 174.745n 0.0v 174.755n 0.0v 179.745n 0.0v 179.755n 0.0v 184.745n 0.0v 184.755n 0.0v 189.745n 0.0v 189.755n 0.0v 194.745n 0.0v 194.755n 0.0v 199.745n 0.0v 199.755n 0.0v 204.745n 0.0v 204.755n 0.0v 209.745n 0.0v 209.755n 0.0v 214.745n 0.0v 214.755n 0.0v 219.745n 0.0v 219.755n 0.0v 224.745n 0.0v 224.755n 1.1v 229.745n 1.1v 229.755n 1.1v 234.745n 1.1v 234.755n 1.1v 239.745n 1.1v 239.755n 1.1v 244.745n 1.1v 244.755n 1.1v 249.745n 1.1v 249.755n 1.1v 254.745n 1.1v 254.755n 1.1v 259.745n 1.1v 259.755n 1.1v 264.745n 1.1v 264.755n 1.1v 269.745n 1.1v 269.755n 1.1v 274.745n 1.1v 274.755n 1.1v 279.745n 1.1v 279.755n 1.1v 284.745n 1.1v 284.755n 1.1v 289.745n 1.1v 289.755n 1.1v 294.745n 1.1v 294.755n 1.1v 299.745n 1.1v 299.755n 1.1v 304.745n 1.1v 304.755n 1.1v 309.745n 1.1v 309.755n 1.1v 314.745n 1.1v 314.755n 1.1v 319.745n 1.1v 319.755n 1.1v 324.745n 1.1v 324.755n 1.1v 329.745n 1.1v 329.755n 1.1v 334.745n 1.1v 334.755n 1.1v 339.745n 1.1v 339.755n 1.1v 344.745n 1.1v 344.755n 1.1v 349.745n 1.1v 349.755n 1.1v 354.745n 1.1v 354.755n 0.0v 359.745n 0.0v 359.755n 0.0v 364.745n 0.0v 364.755n 0.0v 369.745n 0.0v 369.755n 0.0v 374.745n 0.0v 374.755n 0.0v 379.745n 0.0v 379.755n 0.0v 384.745n 0.0v 384.755n 0.0v 389.745n 0.0v 389.755n 0.0v 394.745n 0.0v 394.755n 0.0v 399.745n 0.0v 399.755n 0.0v 404.745n 0.0v 404.755n 0.0v 409.745n 0.0v 409.755n 0.0v 414.745n 0.0v 414.755n 0.0v 419.745n 0.0v 419.755n 1.1v 424.745n 1.1v 424.755n 1.1v 429.745n 1.1v 429.755n 1.1v 434.745n 1.1v 434.755n 1.1v 439.745n 1.1v 439.755n 1.1v 444.745n 1.1v 444.755n 1.1v 449.745n 1.1v 449.755n 1.1v 454.745n 1.1v 454.755n 1.1v 459.745n 1.1v 459.755n 1.1v 464.745n 1.1v 464.755n 1.1v 469.745n 1.1v 469.755n 1.1v 474.745n 1.1v 474.755n 0.0v 479.745n 0.0v 479.755n 0.0v 484.745n 0.0v 484.755n 0.0v 489.745n 0.0v 489.755n 0.0v 494.745n 0.0v 494.755n 0.0v 499.745n 0.0v 499.755n 0.0v 504.745n 0.0v 504.755n 0.0v 509.745n 0.0v 509.755n 0.0v 514.745n 0.0v 514.755n 0.0v 519.745n 0.0v 519.755n 1.1v 524.745n 1.1v 524.755n 1.1v 529.745n 1.1v 529.755n 1.1v 534.745n 1.1v 534.755n 1.1v 539.745n 1.1v 539.755n 1.1v 544.745n 1.1v 544.755n 1.1v 549.745n 1.1v 549.755n 1.1v 554.745n 1.1v 554.755n 1.1v 559.745n 1.1v 559.755n 1.1v 564.745n 1.1v 564.755n 1.1v 569.745n 1.1v 569.755n 1.1v 574.745n 1.1v 574.755n 1.1v 579.745n 1.1v 579.755n 1.1v 584.745n 1.1v 584.755n 1.1v 589.745n 1.1v 589.755n 1.1v 594.745n 1.1v 594.755n 1.1v 599.745n 1.1v 599.755n 1.1v 604.745n 1.1v 604.755n 1.1v 609.745n 1.1v 609.755n 1.1v 614.745n 1.1v 614.755n 1.1v 619.745n 1.1v 619.755n 0.0v 624.745n 0.0v 624.755n 0.0v 629.745n 0.0v 629.755n 0.0v 634.745n 0.0v 634.755n 0.0v 639.745n 0.0v 639.755n 0.0v 644.745n 0.0v 644.755n 0.0v 649.745n 0.0v 649.755n 0.0v 654.745n 0.0v 654.755n 0.0v 659.745n 0.0v 659.755n 1.1v 664.745n 1.1v 664.755n 1.1v 669.745n 1.1v 669.755n 1.1v 674.745n 1.1v 674.755n 0.0v 679.745n 0.0v 679.755n 0.0v 684.745n 0.0v 684.755n 0.0v 689.745n 0.0v 689.755n 0.0v 694.745n 0.0v 694.755n 0.0v 699.745n 0.0v 699.755n 0.0v 704.745n 0.0v 704.755n 0.0v 709.745n 0.0v 709.755n 0.0v 714.745n 0.0v 714.755n 1.1v 719.745n 1.1v 719.755n 1.1v 724.745n 1.1v 724.755n 1.1v 729.745n 1.1v 729.755n 1.1v 734.745n 1.1v 734.755n 1.1v 739.745n 1.1v 739.755n 0.0v 744.745n 0.0v 744.755n 0.0v 749.745n 0.0v 749.755n 0.0v 754.745n 0.0v 754.755n 0.0v 759.745n 0.0v 759.755n 0.0v 764.745n 0.0v 764.755n 0.0v 769.745n 0.0v 769.755n 1.1v 774.745n 1.1v 774.755n 1.1v 779.745n 1.1v 779.755n 1.1v 784.745n 1.1v 784.755n 0.0v 789.745n 0.0v 789.755n 0.0v 794.745n 0.0v 794.755n 0.0v 799.745n 0.0v 799.755n 0.0v 804.745n 0.0v 804.755n 0.0v 809.745n 0.0v 809.755n 0.0v 814.745n 0.0v 814.755n 0.0v 819.745n 0.0v 819.755n 0.0v 824.745n 0.0v 824.755n 0.0v 829.745n 0.0v 829.755n 0.0v 834.745n 0.0v 834.755n 0.0v 839.745n 0.0v 839.755n 0.0v 844.745n 0.0v 844.755n 0.0v 849.745n 0.0v 849.755n 0.0v 854.745n 0.0v 854.755n 0.0v 859.745n 0.0v 859.755n 1.1v 864.745n 1.1v 864.755n 1.1v 869.745n 1.1v 869.755n 1.1v 874.745n 1.1v 874.755n 1.1v 879.745n 1.1v 879.755n 1.1v 884.745n 1.1v 884.755n 1.1v 889.745n 1.1v 889.755n 0.0v 894.745n 0.0v 894.755n 0.0v 899.745n 0.0v 899.755n 1.1v 904.745n 1.1v 904.755n 1.1v 909.745n 1.1v 909.755n 1.1v 914.745n 1.1v 914.755n 1.1v 919.745n 1.1v 919.755n 1.1v 924.745n 1.1v 924.755n 1.1v 929.745n 1.1v 929.755n 1.1v 934.745n 1.1v 934.755n 1.1v 939.745n 1.1v 939.755n 1.1v 944.745n 1.1v 944.755n 1.1v 949.745n 1.1v 949.755n 1.1v 954.745n 1.1v 954.755n 1.1v 959.745n 1.1v 959.755n 1.1v 964.745n 1.1v 964.755n 1.1v 969.745n 1.1v 969.755n 1.1v 974.745n 1.1v 974.755n 0.0v 979.745n 0.0v 979.755n 0.0v 984.745n 0.0v 984.755n 0.0v 989.745n 0.0v 989.755n 0.0v 994.745n 0.0v 994.755n 0.0v 999.745n 0.0v 999.755n 0.0v 1004.745n 0.0v 1004.755n 0.0v 1009.745n 0.0v 1009.755n 0.0v 1014.745n 0.0v 1014.755n 0.0v 1019.745n 0.0v 1019.755n 0.0v 1024.745n 0.0v 1024.755n 0.0v )
* (time, data): [(0, 0), (5, 1), (10, 1), (15, 0), (20, 0), (25, 0), (30, 1), (35, 1), (40, 1), (45, 1), (50, 1), (55, 1), (60, 0), (65, 0), (70, 0), (75, 0), (80, 1), (85, 1), (90, 1), (95, 1), (100, 1), (105, 1), (110, 1), (115, 0), (120, 0), (125, 0), (130, 0), (135, 1), (140, 1), (145, 1), (150, 1), (155, 0), (160, 0), (165, 0), (170, 0), (175, 0), (180, 0), (185, 0), (190, 0), (195, 0), (200, 0), (205, 0), (210, 0), (215, 0), (220, 0), (225, 1), (230, 1), (235, 1), (240, 1), (245, 1), (250, 1), (255, 1), (260, 1), (265, 1), (270, 0), (275, 0), (280, 0), (285, 0), (290, 0), (295, 0), (300, 0), (305, 0), (310, 0), (315, 0), (320, 0), (325, 0), (330, 0), (335, 0), (340, 0), (345, 0), (350, 0), (355, 0), (360, 0), (365, 0), (370, 0), (375, 0), (380, 1), (385, 1), (390, 1), (395, 1), (400, 1), (405, 1), (410, 1), (415, 1), (420, 1), (425, 1), (430, 1), (435, 1), (440, 1), (445, 1), (450, 1), (455, 1), (460, 1), (465, 1), (470, 0), (475, 0), (480, 0), (485, 0), (490, 0), (495, 1), (500, 1), (505, 1), (510, 1), (515, 1), (520, 1), (525, 0), (530, 0), (535, 1), (540, 1), (545, 1), (550, 1), (555, 1), (560, 1), (565, 1), (570, 1), (575, 1), (580, 1), (585, 1), (590, 1), (595, 1), (600, 1), (605, 1), (610, 1), (615, 1), (620, 0), (625, 0), (630, 0), (635, 0), (640, 0), (645, 0), (650, 0), (655, 0), (660, 1), (665, 0), (670, 0), (675, 1), (680, 0), (685, 0), (690, 0), (695, 0), (700, 0), (705, 0), (710, 1), (715, 0), (720, 0), (725, 0), (730, 0), (735, 0), (740, 0), (745, 0), (750, 0), (755, 0), (760, 1), (765, 1), (770, 0), (775, 0), (780, 0), (785, 1), (790, 1), (795, 1), (800, 1), (805, 1), (810, 1), (815, 1), (820, 1), (825, 1), (830, 1), (835, 1), (840, 1), (845, 0), (850, 0), (855, 0), (860, 0), (865, 0), (870, 0), (875, 0), (880, 0), (885, 0), (890, 1), (895, 1), (900, 1), (905, 1), (910, 0), (915, 0), (920, 0), (925, 0), (930, 0), (935, 0), (940, 0), (945, 0), (950, 0), (955, 0), (960, 0), (965, 0), (970, 0), (975, 1), (980, 1), (985, 1), (990, 1), (995, 0), (1000, 0), (1005, 0), (1010, 0), (1015, 0), (1020, 0), (1025, 0)]
Vdin0_21  din0_21  0 PWL (0n 0.0v 4.745n 0.0v 4.755n 1.1v 9.745n 1.1v 9.755n 1.1v 14.745n 1.1v 14.755n 0.0v 19.745n 0.0v 19.755n 0.0v 24.745n 0.0v 24.755n 0.0v 29.745n 0.0v 29.755n 1.1v 34.745n 1.1v 34.755n 1.1v 39.745n 1.1v 39.755n 1.1v 44.745n 1.1v 44.755n 1.1v 49.745n 1.1v 49.755n 1.1v 54.745n 1.1v 54.755n 1.1v 59.745n 1.1v 59.755n 0.0v 64.745n 0.0v 64.755n 0.0v 69.745n 0.0v 69.755n 0.0v 74.745n 0.0v 74.755n 0.0v 79.745n 0.0v 79.755n 1.1v 84.745n 1.1v 84.755n 1.1v 89.745n 1.1v 89.755n 1.1v 94.745n 1.1v 94.755n 1.1v 99.745n 1.1v 99.755n 1.1v 104.745n 1.1v 104.755n 1.1v 109.745n 1.1v 109.755n 1.1v 114.745n 1.1v 114.755n 0.0v 119.745n 0.0v 119.755n 0.0v 124.745n 0.0v 124.755n 0.0v 129.745n 0.0v 129.755n 0.0v 134.745n 0.0v 134.755n 1.1v 139.745n 1.1v 139.755n 1.1v 144.745n 1.1v 144.755n 1.1v 149.745n 1.1v 149.755n 1.1v 154.745n 1.1v 154.755n 0.0v 159.745n 0.0v 159.755n 0.0v 164.745n 0.0v 164.755n 0.0v 169.745n 0.0v 169.755n 0.0v 174.745n 0.0v 174.755n 0.0v 179.745n 0.0v 179.755n 0.0v 184.745n 0.0v 184.755n 0.0v 189.745n 0.0v 189.755n 0.0v 194.745n 0.0v 194.755n 0.0v 199.745n 0.0v 199.755n 0.0v 204.745n 0.0v 204.755n 0.0v 209.745n 0.0v 209.755n 0.0v 214.745n 0.0v 214.755n 0.0v 219.745n 0.0v 219.755n 0.0v 224.745n 0.0v 224.755n 1.1v 229.745n 1.1v 229.755n 1.1v 234.745n 1.1v 234.755n 1.1v 239.745n 1.1v 239.755n 1.1v 244.745n 1.1v 244.755n 1.1v 249.745n 1.1v 249.755n 1.1v 254.745n 1.1v 254.755n 1.1v 259.745n 1.1v 259.755n 1.1v 264.745n 1.1v 264.755n 1.1v 269.745n 1.1v 269.755n 0.0v 274.745n 0.0v 274.755n 0.0v 279.745n 0.0v 279.755n 0.0v 284.745n 0.0v 284.755n 0.0v 289.745n 0.0v 289.755n 0.0v 294.745n 0.0v 294.755n 0.0v 299.745n 0.0v 299.755n 0.0v 304.745n 0.0v 304.755n 0.0v 309.745n 0.0v 309.755n 0.0v 314.745n 0.0v 314.755n 0.0v 319.745n 0.0v 319.755n 0.0v 324.745n 0.0v 324.755n 0.0v 329.745n 0.0v 329.755n 0.0v 334.745n 0.0v 334.755n 0.0v 339.745n 0.0v 339.755n 0.0v 344.745n 0.0v 344.755n 0.0v 349.745n 0.0v 349.755n 0.0v 354.745n 0.0v 354.755n 0.0v 359.745n 0.0v 359.755n 0.0v 364.745n 0.0v 364.755n 0.0v 369.745n 0.0v 369.755n 0.0v 374.745n 0.0v 374.755n 0.0v 379.745n 0.0v 379.755n 1.1v 384.745n 1.1v 384.755n 1.1v 389.745n 1.1v 389.755n 1.1v 394.745n 1.1v 394.755n 1.1v 399.745n 1.1v 399.755n 1.1v 404.745n 1.1v 404.755n 1.1v 409.745n 1.1v 409.755n 1.1v 414.745n 1.1v 414.755n 1.1v 419.745n 1.1v 419.755n 1.1v 424.745n 1.1v 424.755n 1.1v 429.745n 1.1v 429.755n 1.1v 434.745n 1.1v 434.755n 1.1v 439.745n 1.1v 439.755n 1.1v 444.745n 1.1v 444.755n 1.1v 449.745n 1.1v 449.755n 1.1v 454.745n 1.1v 454.755n 1.1v 459.745n 1.1v 459.755n 1.1v 464.745n 1.1v 464.755n 1.1v 469.745n 1.1v 469.755n 0.0v 474.745n 0.0v 474.755n 0.0v 479.745n 0.0v 479.755n 0.0v 484.745n 0.0v 484.755n 0.0v 489.745n 0.0v 489.755n 0.0v 494.745n 0.0v 494.755n 1.1v 499.745n 1.1v 499.755n 1.1v 504.745n 1.1v 504.755n 1.1v 509.745n 1.1v 509.755n 1.1v 514.745n 1.1v 514.755n 1.1v 519.745n 1.1v 519.755n 1.1v 524.745n 1.1v 524.755n 0.0v 529.745n 0.0v 529.755n 0.0v 534.745n 0.0v 534.755n 1.1v 539.745n 1.1v 539.755n 1.1v 544.745n 1.1v 544.755n 1.1v 549.745n 1.1v 549.755n 1.1v 554.745n 1.1v 554.755n 1.1v 559.745n 1.1v 559.755n 1.1v 564.745n 1.1v 564.755n 1.1v 569.745n 1.1v 569.755n 1.1v 574.745n 1.1v 574.755n 1.1v 579.745n 1.1v 579.755n 1.1v 584.745n 1.1v 584.755n 1.1v 589.745n 1.1v 589.755n 1.1v 594.745n 1.1v 594.755n 1.1v 599.745n 1.1v 599.755n 1.1v 604.745n 1.1v 604.755n 1.1v 609.745n 1.1v 609.755n 1.1v 614.745n 1.1v 614.755n 1.1v 619.745n 1.1v 619.755n 0.0v 624.745n 0.0v 624.755n 0.0v 629.745n 0.0v 629.755n 0.0v 634.745n 0.0v 634.755n 0.0v 639.745n 0.0v 639.755n 0.0v 644.745n 0.0v 644.755n 0.0v 649.745n 0.0v 649.755n 0.0v 654.745n 0.0v 654.755n 0.0v 659.745n 0.0v 659.755n 1.1v 664.745n 1.1v 664.755n 0.0v 669.745n 0.0v 669.755n 0.0v 674.745n 0.0v 674.755n 1.1v 679.745n 1.1v 679.755n 0.0v 684.745n 0.0v 684.755n 0.0v 689.745n 0.0v 689.755n 0.0v 694.745n 0.0v 694.755n 0.0v 699.745n 0.0v 699.755n 0.0v 704.745n 0.0v 704.755n 0.0v 709.745n 0.0v 709.755n 1.1v 714.745n 1.1v 714.755n 0.0v 719.745n 0.0v 719.755n 0.0v 724.745n 0.0v 724.755n 0.0v 729.745n 0.0v 729.755n 0.0v 734.745n 0.0v 734.755n 0.0v 739.745n 0.0v 739.755n 0.0v 744.745n 0.0v 744.755n 0.0v 749.745n 0.0v 749.755n 0.0v 754.745n 0.0v 754.755n 0.0v 759.745n 0.0v 759.755n 1.1v 764.745n 1.1v 764.755n 1.1v 769.745n 1.1v 769.755n 0.0v 774.745n 0.0v 774.755n 0.0v 779.745n 0.0v 779.755n 0.0v 784.745n 0.0v 784.755n 1.1v 789.745n 1.1v 789.755n 1.1v 794.745n 1.1v 794.755n 1.1v 799.745n 1.1v 799.755n 1.1v 804.745n 1.1v 804.755n 1.1v 809.745n 1.1v 809.755n 1.1v 814.745n 1.1v 814.755n 1.1v 819.745n 1.1v 819.755n 1.1v 824.745n 1.1v 824.755n 1.1v 829.745n 1.1v 829.755n 1.1v 834.745n 1.1v 834.755n 1.1v 839.745n 1.1v 839.755n 1.1v 844.745n 1.1v 844.755n 0.0v 849.745n 0.0v 849.755n 0.0v 854.745n 0.0v 854.755n 0.0v 859.745n 0.0v 859.755n 0.0v 864.745n 0.0v 864.755n 0.0v 869.745n 0.0v 869.755n 0.0v 874.745n 0.0v 874.755n 0.0v 879.745n 0.0v 879.755n 0.0v 884.745n 0.0v 884.755n 0.0v 889.745n 0.0v 889.755n 1.1v 894.745n 1.1v 894.755n 1.1v 899.745n 1.1v 899.755n 1.1v 904.745n 1.1v 904.755n 1.1v 909.745n 1.1v 909.755n 0.0v 914.745n 0.0v 914.755n 0.0v 919.745n 0.0v 919.755n 0.0v 924.745n 0.0v 924.755n 0.0v 929.745n 0.0v 929.755n 0.0v 934.745n 0.0v 934.755n 0.0v 939.745n 0.0v 939.755n 0.0v 944.745n 0.0v 944.755n 0.0v 949.745n 0.0v 949.755n 0.0v 954.745n 0.0v 954.755n 0.0v 959.745n 0.0v 959.755n 0.0v 964.745n 0.0v 964.755n 0.0v 969.745n 0.0v 969.755n 0.0v 974.745n 0.0v 974.755n 1.1v 979.745n 1.1v 979.755n 1.1v 984.745n 1.1v 984.755n 1.1v 989.745n 1.1v 989.755n 1.1v 994.745n 1.1v 994.755n 0.0v 999.745n 0.0v 999.755n 0.0v 1004.745n 0.0v 1004.755n 0.0v 1009.745n 0.0v 1009.755n 0.0v 1014.745n 0.0v 1014.755n 0.0v 1019.745n 0.0v 1019.755n 0.0v 1024.745n 0.0v 1024.755n 0.0v )
* (time, data): [(0, 0), (5, 1), (10, 1), (15, 0), (20, 0), (25, 0), (30, 1), (35, 1), (40, 1), (45, 1), (50, 1), (55, 1), (60, 1), (65, 0), (70, 0), (75, 0), (80, 0), (85, 0), (90, 0), (95, 1), (100, 1), (105, 1), (110, 1), (115, 1), (120, 1), (125, 1), (130, 1), (135, 0), (140, 0), (145, 0), (150, 1), (155, 0), (160, 0), (165, 0), (170, 0), (175, 0), (180, 0), (185, 0), (190, 0), (195, 0), (200, 0), (205, 0), (210, 0), (215, 0), (220, 0), (225, 0), (230, 0), (235, 0), (240, 0), (245, 0), (250, 0), (255, 0), (260, 0), (265, 1), (270, 0), (275, 0), (280, 0), (285, 0), (290, 0), (295, 0), (300, 0), (305, 0), (310, 0), (315, 0), (320, 0), (325, 0), (330, 0), (335, 0), (340, 0), (345, 0), (350, 0), (355, 1), (360, 1), (365, 1), (370, 1), (375, 1), (380, 1), (385, 1), (390, 1), (395, 1), (400, 1), (405, 1), (410, 1), (415, 1), (420, 1), (425, 1), (430, 1), (435, 1), (440, 1), (445, 1), (450, 1), (455, 1), (460, 1), (465, 1), (470, 0), (475, 0), (480, 0), (485, 0), (490, 0), (495, 0), (500, 0), (505, 0), (510, 0), (515, 0), (520, 1), (525, 0), (530, 0), (535, 1), (540, 1), (545, 1), (550, 1), (555, 1), (560, 1), (565, 1), (570, 1), (575, 1), (580, 1), (585, 1), (590, 1), (595, 1), (600, 1), (605, 1), (610, 1), (615, 1), (620, 0), (625, 0), (630, 0), (635, 0), (640, 0), (645, 0), (650, 0), (655, 0), (660, 1), (665, 1), (670, 1), (675, 0), (680, 1), (685, 1), (690, 1), (695, 1), (700, 1), (705, 1), (710, 0), (715, 1), (720, 1), (725, 1), (730, 1), (735, 1), (740, 1), (745, 1), (750, 1), (755, 1), (760, 0), (765, 0), (770, 1), (775, 1), (780, 1), (785, 1), (790, 1), (795, 1), (800, 1), (805, 1), (810, 1), (815, 1), (820, 1), (825, 1), (830, 1), (835, 1), (840, 1), (845, 1), (850, 1), (855, 1), (860, 1), (865, 0), (870, 0), (875, 1), (880, 1), (885, 1), (890, 1), (895, 1), (900, 1), (905, 1), (910, 0), (915, 0), (920, 0), (925, 0), (930, 0), (935, 0), (940, 0), (945, 0), (950, 0), (955, 0), (960, 0), (965, 0), (970, 0), (975, 1), (980, 1), (985, 1), (990, 1), (995, 0), (1000, 0), (1005, 0), (1010, 0), (1015, 0), (1020, 0), (1025, 0)]
Vdin0_22  din0_22  0 PWL (0n 0.0v 4.745n 0.0v 4.755n 1.1v 9.745n 1.1v 9.755n 1.1v 14.745n 1.1v 14.755n 0.0v 19.745n 0.0v 19.755n 0.0v 24.745n 0.0v 24.755n 0.0v 29.745n 0.0v 29.755n 1.1v 34.745n 1.1v 34.755n 1.1v 39.745n 1.1v 39.755n 1.1v 44.745n 1.1v 44.755n 1.1v 49.745n 1.1v 49.755n 1.1v 54.745n 1.1v 54.755n 1.1v 59.745n 1.1v 59.755n 1.1v 64.745n 1.1v 64.755n 0.0v 69.745n 0.0v 69.755n 0.0v 74.745n 0.0v 74.755n 0.0v 79.745n 0.0v 79.755n 0.0v 84.745n 0.0v 84.755n 0.0v 89.745n 0.0v 89.755n 0.0v 94.745n 0.0v 94.755n 1.1v 99.745n 1.1v 99.755n 1.1v 104.745n 1.1v 104.755n 1.1v 109.745n 1.1v 109.755n 1.1v 114.745n 1.1v 114.755n 1.1v 119.745n 1.1v 119.755n 1.1v 124.745n 1.1v 124.755n 1.1v 129.745n 1.1v 129.755n 1.1v 134.745n 1.1v 134.755n 0.0v 139.745n 0.0v 139.755n 0.0v 144.745n 0.0v 144.755n 0.0v 149.745n 0.0v 149.755n 1.1v 154.745n 1.1v 154.755n 0.0v 159.745n 0.0v 159.755n 0.0v 164.745n 0.0v 164.755n 0.0v 169.745n 0.0v 169.755n 0.0v 174.745n 0.0v 174.755n 0.0v 179.745n 0.0v 179.755n 0.0v 184.745n 0.0v 184.755n 0.0v 189.745n 0.0v 189.755n 0.0v 194.745n 0.0v 194.755n 0.0v 199.745n 0.0v 199.755n 0.0v 204.745n 0.0v 204.755n 0.0v 209.745n 0.0v 209.755n 0.0v 214.745n 0.0v 214.755n 0.0v 219.745n 0.0v 219.755n 0.0v 224.745n 0.0v 224.755n 0.0v 229.745n 0.0v 229.755n 0.0v 234.745n 0.0v 234.755n 0.0v 239.745n 0.0v 239.755n 0.0v 244.745n 0.0v 244.755n 0.0v 249.745n 0.0v 249.755n 0.0v 254.745n 0.0v 254.755n 0.0v 259.745n 0.0v 259.755n 0.0v 264.745n 0.0v 264.755n 1.1v 269.745n 1.1v 269.755n 0.0v 274.745n 0.0v 274.755n 0.0v 279.745n 0.0v 279.755n 0.0v 284.745n 0.0v 284.755n 0.0v 289.745n 0.0v 289.755n 0.0v 294.745n 0.0v 294.755n 0.0v 299.745n 0.0v 299.755n 0.0v 304.745n 0.0v 304.755n 0.0v 309.745n 0.0v 309.755n 0.0v 314.745n 0.0v 314.755n 0.0v 319.745n 0.0v 319.755n 0.0v 324.745n 0.0v 324.755n 0.0v 329.745n 0.0v 329.755n 0.0v 334.745n 0.0v 334.755n 0.0v 339.745n 0.0v 339.755n 0.0v 344.745n 0.0v 344.755n 0.0v 349.745n 0.0v 349.755n 0.0v 354.745n 0.0v 354.755n 1.1v 359.745n 1.1v 359.755n 1.1v 364.745n 1.1v 364.755n 1.1v 369.745n 1.1v 369.755n 1.1v 374.745n 1.1v 374.755n 1.1v 379.745n 1.1v 379.755n 1.1v 384.745n 1.1v 384.755n 1.1v 389.745n 1.1v 389.755n 1.1v 394.745n 1.1v 394.755n 1.1v 399.745n 1.1v 399.755n 1.1v 404.745n 1.1v 404.755n 1.1v 409.745n 1.1v 409.755n 1.1v 414.745n 1.1v 414.755n 1.1v 419.745n 1.1v 419.755n 1.1v 424.745n 1.1v 424.755n 1.1v 429.745n 1.1v 429.755n 1.1v 434.745n 1.1v 434.755n 1.1v 439.745n 1.1v 439.755n 1.1v 444.745n 1.1v 444.755n 1.1v 449.745n 1.1v 449.755n 1.1v 454.745n 1.1v 454.755n 1.1v 459.745n 1.1v 459.755n 1.1v 464.745n 1.1v 464.755n 1.1v 469.745n 1.1v 469.755n 0.0v 474.745n 0.0v 474.755n 0.0v 479.745n 0.0v 479.755n 0.0v 484.745n 0.0v 484.755n 0.0v 489.745n 0.0v 489.755n 0.0v 494.745n 0.0v 494.755n 0.0v 499.745n 0.0v 499.755n 0.0v 504.745n 0.0v 504.755n 0.0v 509.745n 0.0v 509.755n 0.0v 514.745n 0.0v 514.755n 0.0v 519.745n 0.0v 519.755n 1.1v 524.745n 1.1v 524.755n 0.0v 529.745n 0.0v 529.755n 0.0v 534.745n 0.0v 534.755n 1.1v 539.745n 1.1v 539.755n 1.1v 544.745n 1.1v 544.755n 1.1v 549.745n 1.1v 549.755n 1.1v 554.745n 1.1v 554.755n 1.1v 559.745n 1.1v 559.755n 1.1v 564.745n 1.1v 564.755n 1.1v 569.745n 1.1v 569.755n 1.1v 574.745n 1.1v 574.755n 1.1v 579.745n 1.1v 579.755n 1.1v 584.745n 1.1v 584.755n 1.1v 589.745n 1.1v 589.755n 1.1v 594.745n 1.1v 594.755n 1.1v 599.745n 1.1v 599.755n 1.1v 604.745n 1.1v 604.755n 1.1v 609.745n 1.1v 609.755n 1.1v 614.745n 1.1v 614.755n 1.1v 619.745n 1.1v 619.755n 0.0v 624.745n 0.0v 624.755n 0.0v 629.745n 0.0v 629.755n 0.0v 634.745n 0.0v 634.755n 0.0v 639.745n 0.0v 639.755n 0.0v 644.745n 0.0v 644.755n 0.0v 649.745n 0.0v 649.755n 0.0v 654.745n 0.0v 654.755n 0.0v 659.745n 0.0v 659.755n 1.1v 664.745n 1.1v 664.755n 1.1v 669.745n 1.1v 669.755n 1.1v 674.745n 1.1v 674.755n 0.0v 679.745n 0.0v 679.755n 1.1v 684.745n 1.1v 684.755n 1.1v 689.745n 1.1v 689.755n 1.1v 694.745n 1.1v 694.755n 1.1v 699.745n 1.1v 699.755n 1.1v 704.745n 1.1v 704.755n 1.1v 709.745n 1.1v 709.755n 0.0v 714.745n 0.0v 714.755n 1.1v 719.745n 1.1v 719.755n 1.1v 724.745n 1.1v 724.755n 1.1v 729.745n 1.1v 729.755n 1.1v 734.745n 1.1v 734.755n 1.1v 739.745n 1.1v 739.755n 1.1v 744.745n 1.1v 744.755n 1.1v 749.745n 1.1v 749.755n 1.1v 754.745n 1.1v 754.755n 1.1v 759.745n 1.1v 759.755n 0.0v 764.745n 0.0v 764.755n 0.0v 769.745n 0.0v 769.755n 1.1v 774.745n 1.1v 774.755n 1.1v 779.745n 1.1v 779.755n 1.1v 784.745n 1.1v 784.755n 1.1v 789.745n 1.1v 789.755n 1.1v 794.745n 1.1v 794.755n 1.1v 799.745n 1.1v 799.755n 1.1v 804.745n 1.1v 804.755n 1.1v 809.745n 1.1v 809.755n 1.1v 814.745n 1.1v 814.755n 1.1v 819.745n 1.1v 819.755n 1.1v 824.745n 1.1v 824.755n 1.1v 829.745n 1.1v 829.755n 1.1v 834.745n 1.1v 834.755n 1.1v 839.745n 1.1v 839.755n 1.1v 844.745n 1.1v 844.755n 1.1v 849.745n 1.1v 849.755n 1.1v 854.745n 1.1v 854.755n 1.1v 859.745n 1.1v 859.755n 1.1v 864.745n 1.1v 864.755n 0.0v 869.745n 0.0v 869.755n 0.0v 874.745n 0.0v 874.755n 1.1v 879.745n 1.1v 879.755n 1.1v 884.745n 1.1v 884.755n 1.1v 889.745n 1.1v 889.755n 1.1v 894.745n 1.1v 894.755n 1.1v 899.745n 1.1v 899.755n 1.1v 904.745n 1.1v 904.755n 1.1v 909.745n 1.1v 909.755n 0.0v 914.745n 0.0v 914.755n 0.0v 919.745n 0.0v 919.755n 0.0v 924.745n 0.0v 924.755n 0.0v 929.745n 0.0v 929.755n 0.0v 934.745n 0.0v 934.755n 0.0v 939.745n 0.0v 939.755n 0.0v 944.745n 0.0v 944.755n 0.0v 949.745n 0.0v 949.755n 0.0v 954.745n 0.0v 954.755n 0.0v 959.745n 0.0v 959.755n 0.0v 964.745n 0.0v 964.755n 0.0v 969.745n 0.0v 969.755n 0.0v 974.745n 0.0v 974.755n 1.1v 979.745n 1.1v 979.755n 1.1v 984.745n 1.1v 984.755n 1.1v 989.745n 1.1v 989.755n 1.1v 994.745n 1.1v 994.755n 0.0v 999.745n 0.0v 999.755n 0.0v 1004.745n 0.0v 1004.755n 0.0v 1009.745n 0.0v 1009.755n 0.0v 1014.745n 0.0v 1014.755n 0.0v 1019.745n 0.0v 1019.755n 0.0v 1024.745n 0.0v 1024.755n 0.0v )
* (time, data): [(0, 0), (5, 1), (10, 1), (15, 1), (20, 1), (25, 1), (30, 0), (35, 1), (40, 1), (45, 1), (50, 1), (55, 1), (60, 1), (65, 0), (70, 0), (75, 0), (80, 0), (85, 0), (90, 0), (95, 0), (100, 0), (105, 0), (110, 1), (115, 0), (120, 0), (125, 0), (130, 1), (135, 1), (140, 1), (145, 1), (150, 1), (155, 0), (160, 0), (165, 0), (170, 0), (175, 0), (180, 0), (185, 0), (190, 0), (195, 0), (200, 0), (205, 0), (210, 0), (215, 0), (220, 0), (225, 1), (230, 1), (235, 1), (240, 1), (245, 1), (250, 1), (255, 1), (260, 1), (265, 0), (270, 0), (275, 0), (280, 0), (285, 0), (290, 0), (295, 0), (300, 0), (305, 0), (310, 0), (315, 0), (320, 0), (325, 0), (330, 0), (335, 0), (340, 0), (345, 0), (350, 0), (355, 1), (360, 1), (365, 1), (370, 1), (375, 1), (380, 0), (385, 0), (390, 0), (395, 0), (400, 0), (405, 0), (410, 0), (415, 0), (420, 0), (425, 0), (430, 0), (435, 0), (440, 0), (445, 0), (450, 0), (455, 0), (460, 0), (465, 0), (470, 0), (475, 1), (480, 1), (485, 1), (490, 1), (495, 1), (500, 1), (505, 1), (510, 1), (515, 1), (520, 1), (525, 0), (530, 0), (535, 1), (540, 1), (545, 1), (550, 1), (555, 1), (560, 1), (565, 1), (570, 1), (575, 1), (580, 1), (585, 1), (590, 1), (595, 1), (600, 1), (605, 1), (610, 1), (615, 1), (620, 0), (625, 0), (630, 0), (635, 0), (640, 0), (645, 0), (650, 0), (655, 0), (660, 1), (665, 1), (670, 1), (675, 1), (680, 0), (685, 0), (690, 0), (695, 0), (700, 0), (705, 0), (710, 1), (715, 1), (720, 1), (725, 1), (730, 1), (735, 1), (740, 0), (745, 0), (750, 0), (755, 0), (760, 0), (765, 0), (770, 1), (775, 1), (780, 1), (785, 1), (790, 1), (795, 0), (800, 0), (805, 0), (810, 0), (815, 0), (820, 0), (825, 0), (830, 0), (835, 0), (840, 0), (845, 0), (850, 0), (855, 0), (860, 1), (865, 0), (870, 0), (875, 1), (880, 1), (885, 1), (890, 1), (895, 1), (900, 0), (905, 0), (910, 0), (915, 0), (920, 0), (925, 0), (930, 0), (935, 0), (940, 0), (945, 0), (950, 0), (955, 0), (960, 0), (965, 0), (970, 0), (975, 1), (980, 1), (985, 1), (990, 1), (995, 1), (1000, 1), (1005, 1), (1010, 1), (1015, 1), (1020, 1), (1025, 1)]
Vdin0_23  din0_23  0 PWL (0n 0.0v 4.745n 0.0v 4.755n 1.1v 9.745n 1.1v 9.755n 1.1v 14.745n 1.1v 14.755n 1.1v 19.745n 1.1v 19.755n 1.1v 24.745n 1.1v 24.755n 1.1v 29.745n 1.1v 29.755n 0.0v 34.745n 0.0v 34.755n 1.1v 39.745n 1.1v 39.755n 1.1v 44.745n 1.1v 44.755n 1.1v 49.745n 1.1v 49.755n 1.1v 54.745n 1.1v 54.755n 1.1v 59.745n 1.1v 59.755n 1.1v 64.745n 1.1v 64.755n 0.0v 69.745n 0.0v 69.755n 0.0v 74.745n 0.0v 74.755n 0.0v 79.745n 0.0v 79.755n 0.0v 84.745n 0.0v 84.755n 0.0v 89.745n 0.0v 89.755n 0.0v 94.745n 0.0v 94.755n 0.0v 99.745n 0.0v 99.755n 0.0v 104.745n 0.0v 104.755n 0.0v 109.745n 0.0v 109.755n 1.1v 114.745n 1.1v 114.755n 0.0v 119.745n 0.0v 119.755n 0.0v 124.745n 0.0v 124.755n 0.0v 129.745n 0.0v 129.755n 1.1v 134.745n 1.1v 134.755n 1.1v 139.745n 1.1v 139.755n 1.1v 144.745n 1.1v 144.755n 1.1v 149.745n 1.1v 149.755n 1.1v 154.745n 1.1v 154.755n 0.0v 159.745n 0.0v 159.755n 0.0v 164.745n 0.0v 164.755n 0.0v 169.745n 0.0v 169.755n 0.0v 174.745n 0.0v 174.755n 0.0v 179.745n 0.0v 179.755n 0.0v 184.745n 0.0v 184.755n 0.0v 189.745n 0.0v 189.755n 0.0v 194.745n 0.0v 194.755n 0.0v 199.745n 0.0v 199.755n 0.0v 204.745n 0.0v 204.755n 0.0v 209.745n 0.0v 209.755n 0.0v 214.745n 0.0v 214.755n 0.0v 219.745n 0.0v 219.755n 0.0v 224.745n 0.0v 224.755n 1.1v 229.745n 1.1v 229.755n 1.1v 234.745n 1.1v 234.755n 1.1v 239.745n 1.1v 239.755n 1.1v 244.745n 1.1v 244.755n 1.1v 249.745n 1.1v 249.755n 1.1v 254.745n 1.1v 254.755n 1.1v 259.745n 1.1v 259.755n 1.1v 264.745n 1.1v 264.755n 0.0v 269.745n 0.0v 269.755n 0.0v 274.745n 0.0v 274.755n 0.0v 279.745n 0.0v 279.755n 0.0v 284.745n 0.0v 284.755n 0.0v 289.745n 0.0v 289.755n 0.0v 294.745n 0.0v 294.755n 0.0v 299.745n 0.0v 299.755n 0.0v 304.745n 0.0v 304.755n 0.0v 309.745n 0.0v 309.755n 0.0v 314.745n 0.0v 314.755n 0.0v 319.745n 0.0v 319.755n 0.0v 324.745n 0.0v 324.755n 0.0v 329.745n 0.0v 329.755n 0.0v 334.745n 0.0v 334.755n 0.0v 339.745n 0.0v 339.755n 0.0v 344.745n 0.0v 344.755n 0.0v 349.745n 0.0v 349.755n 0.0v 354.745n 0.0v 354.755n 1.1v 359.745n 1.1v 359.755n 1.1v 364.745n 1.1v 364.755n 1.1v 369.745n 1.1v 369.755n 1.1v 374.745n 1.1v 374.755n 1.1v 379.745n 1.1v 379.755n 0.0v 384.745n 0.0v 384.755n 0.0v 389.745n 0.0v 389.755n 0.0v 394.745n 0.0v 394.755n 0.0v 399.745n 0.0v 399.755n 0.0v 404.745n 0.0v 404.755n 0.0v 409.745n 0.0v 409.755n 0.0v 414.745n 0.0v 414.755n 0.0v 419.745n 0.0v 419.755n 0.0v 424.745n 0.0v 424.755n 0.0v 429.745n 0.0v 429.755n 0.0v 434.745n 0.0v 434.755n 0.0v 439.745n 0.0v 439.755n 0.0v 444.745n 0.0v 444.755n 0.0v 449.745n 0.0v 449.755n 0.0v 454.745n 0.0v 454.755n 0.0v 459.745n 0.0v 459.755n 0.0v 464.745n 0.0v 464.755n 0.0v 469.745n 0.0v 469.755n 0.0v 474.745n 0.0v 474.755n 1.1v 479.745n 1.1v 479.755n 1.1v 484.745n 1.1v 484.755n 1.1v 489.745n 1.1v 489.755n 1.1v 494.745n 1.1v 494.755n 1.1v 499.745n 1.1v 499.755n 1.1v 504.745n 1.1v 504.755n 1.1v 509.745n 1.1v 509.755n 1.1v 514.745n 1.1v 514.755n 1.1v 519.745n 1.1v 519.755n 1.1v 524.745n 1.1v 524.755n 0.0v 529.745n 0.0v 529.755n 0.0v 534.745n 0.0v 534.755n 1.1v 539.745n 1.1v 539.755n 1.1v 544.745n 1.1v 544.755n 1.1v 549.745n 1.1v 549.755n 1.1v 554.745n 1.1v 554.755n 1.1v 559.745n 1.1v 559.755n 1.1v 564.745n 1.1v 564.755n 1.1v 569.745n 1.1v 569.755n 1.1v 574.745n 1.1v 574.755n 1.1v 579.745n 1.1v 579.755n 1.1v 584.745n 1.1v 584.755n 1.1v 589.745n 1.1v 589.755n 1.1v 594.745n 1.1v 594.755n 1.1v 599.745n 1.1v 599.755n 1.1v 604.745n 1.1v 604.755n 1.1v 609.745n 1.1v 609.755n 1.1v 614.745n 1.1v 614.755n 1.1v 619.745n 1.1v 619.755n 0.0v 624.745n 0.0v 624.755n 0.0v 629.745n 0.0v 629.755n 0.0v 634.745n 0.0v 634.755n 0.0v 639.745n 0.0v 639.755n 0.0v 644.745n 0.0v 644.755n 0.0v 649.745n 0.0v 649.755n 0.0v 654.745n 0.0v 654.755n 0.0v 659.745n 0.0v 659.755n 1.1v 664.745n 1.1v 664.755n 1.1v 669.745n 1.1v 669.755n 1.1v 674.745n 1.1v 674.755n 1.1v 679.745n 1.1v 679.755n 0.0v 684.745n 0.0v 684.755n 0.0v 689.745n 0.0v 689.755n 0.0v 694.745n 0.0v 694.755n 0.0v 699.745n 0.0v 699.755n 0.0v 704.745n 0.0v 704.755n 0.0v 709.745n 0.0v 709.755n 1.1v 714.745n 1.1v 714.755n 1.1v 719.745n 1.1v 719.755n 1.1v 724.745n 1.1v 724.755n 1.1v 729.745n 1.1v 729.755n 1.1v 734.745n 1.1v 734.755n 1.1v 739.745n 1.1v 739.755n 0.0v 744.745n 0.0v 744.755n 0.0v 749.745n 0.0v 749.755n 0.0v 754.745n 0.0v 754.755n 0.0v 759.745n 0.0v 759.755n 0.0v 764.745n 0.0v 764.755n 0.0v 769.745n 0.0v 769.755n 1.1v 774.745n 1.1v 774.755n 1.1v 779.745n 1.1v 779.755n 1.1v 784.745n 1.1v 784.755n 1.1v 789.745n 1.1v 789.755n 1.1v 794.745n 1.1v 794.755n 0.0v 799.745n 0.0v 799.755n 0.0v 804.745n 0.0v 804.755n 0.0v 809.745n 0.0v 809.755n 0.0v 814.745n 0.0v 814.755n 0.0v 819.745n 0.0v 819.755n 0.0v 824.745n 0.0v 824.755n 0.0v 829.745n 0.0v 829.755n 0.0v 834.745n 0.0v 834.755n 0.0v 839.745n 0.0v 839.755n 0.0v 844.745n 0.0v 844.755n 0.0v 849.745n 0.0v 849.755n 0.0v 854.745n 0.0v 854.755n 0.0v 859.745n 0.0v 859.755n 1.1v 864.745n 1.1v 864.755n 0.0v 869.745n 0.0v 869.755n 0.0v 874.745n 0.0v 874.755n 1.1v 879.745n 1.1v 879.755n 1.1v 884.745n 1.1v 884.755n 1.1v 889.745n 1.1v 889.755n 1.1v 894.745n 1.1v 894.755n 1.1v 899.745n 1.1v 899.755n 0.0v 904.745n 0.0v 904.755n 0.0v 909.745n 0.0v 909.755n 0.0v 914.745n 0.0v 914.755n 0.0v 919.745n 0.0v 919.755n 0.0v 924.745n 0.0v 924.755n 0.0v 929.745n 0.0v 929.755n 0.0v 934.745n 0.0v 934.755n 0.0v 939.745n 0.0v 939.755n 0.0v 944.745n 0.0v 944.755n 0.0v 949.745n 0.0v 949.755n 0.0v 954.745n 0.0v 954.755n 0.0v 959.745n 0.0v 959.755n 0.0v 964.745n 0.0v 964.755n 0.0v 969.745n 0.0v 969.755n 0.0v 974.745n 0.0v 974.755n 1.1v 979.745n 1.1v 979.755n 1.1v 984.745n 1.1v 984.755n 1.1v 989.745n 1.1v 989.755n 1.1v 994.745n 1.1v 994.755n 1.1v 999.745n 1.1v 999.755n 1.1v 1004.745n 1.1v 1004.755n 1.1v 1009.745n 1.1v 1009.755n 1.1v 1014.745n 1.1v 1014.755n 1.1v 1019.745n 1.1v 1019.755n 1.1v 1024.745n 1.1v 1024.755n 1.1v )
* (time, data): [(0, 0), (5, 1), (10, 1), (15, 1), (20, 1), (25, 1), (30, 1), (35, 1), (40, 1), (45, 1), (50, 1), (55, 1), (60, 0), (65, 1), (70, 1), (75, 1), (80, 0), (85, 0), (90, 0), (95, 0), (100, 0), (105, 0), (110, 0), (115, 0), (120, 0), (125, 0), (130, 0), (135, 1), (140, 1), (145, 1), (150, 1), (155, 1), (160, 1), (165, 1), (170, 1), (175, 1), (180, 1), (185, 1), (190, 1), (195, 1), (200, 1), (205, 1), (210, 1), (215, 1), (220, 1), (225, 1), (230, 1), (235, 1), (240, 1), (245, 1), (250, 1), (255, 1), (260, 1), (265, 1), (270, 0), (275, 0), (280, 0), (285, 0), (290, 0), (295, 0), (300, 0), (305, 0), (310, 0), (315, 0), (320, 0), (325, 0), (330, 0), (335, 0), (340, 0), (345, 0), (350, 0), (355, 1), (360, 1), (365, 1), (370, 1), (375, 1), (380, 0), (385, 0), (390, 0), (395, 0), (400, 0), (405, 0), (410, 0), (415, 0), (420, 0), (425, 0), (430, 0), (435, 0), (440, 0), (445, 0), (450, 0), (455, 0), (460, 0), (465, 0), (470, 1), (475, 0), (480, 0), (485, 0), (490, 0), (495, 0), (500, 0), (505, 0), (510, 0), (515, 0), (520, 1), (525, 0), (530, 0), (535, 0), (540, 0), (545, 0), (550, 0), (555, 0), (560, 0), (565, 0), (570, 0), (575, 0), (580, 0), (585, 0), (590, 0), (595, 0), (600, 0), (605, 0), (610, 0), (615, 0), (620, 0), (625, 0), (630, 0), (635, 0), (640, 0), (645, 1), (650, 1), (655, 1), (660, 1), (665, 1), (670, 1), (675, 1), (680, 1), (685, 1), (690, 1), (695, 1), (700, 1), (705, 1), (710, 0), (715, 1), (720, 1), (725, 1), (730, 1), (735, 1), (740, 1), (745, 1), (750, 1), (755, 1), (760, 1), (765, 1), (770, 0), (775, 0), (780, 0), (785, 1), (790, 0), (795, 1), (800, 1), (805, 1), (810, 1), (815, 1), (820, 1), (825, 1), (830, 1), (835, 1), (840, 1), (845, 0), (850, 0), (855, 0), (860, 0), (865, 0), (870, 0), (875, 0), (880, 0), (885, 0), (890, 1), (895, 1), (900, 1), (905, 1), (910, 0), (915, 0), (920, 0), (925, 0), (930, 0), (935, 0), (940, 0), (945, 0), (950, 0), (955, 0), (960, 0), (965, 0), (970, 0), (975, 0), (980, 0), (985, 0), (990, 0), (995, 1), (1000, 1), (1005, 0), (1010, 0), (1015, 0), (1020, 0), (1025, 0)]
Vdin0_24  din0_24  0 PWL (0n 0.0v 4.745n 0.0v 4.755n 1.1v 9.745n 1.1v 9.755n 1.1v 14.745n 1.1v 14.755n 1.1v 19.745n 1.1v 19.755n 1.1v 24.745n 1.1v 24.755n 1.1v 29.745n 1.1v 29.755n 1.1v 34.745n 1.1v 34.755n 1.1v 39.745n 1.1v 39.755n 1.1v 44.745n 1.1v 44.755n 1.1v 49.745n 1.1v 49.755n 1.1v 54.745n 1.1v 54.755n 1.1v 59.745n 1.1v 59.755n 0.0v 64.745n 0.0v 64.755n 1.1v 69.745n 1.1v 69.755n 1.1v 74.745n 1.1v 74.755n 1.1v 79.745n 1.1v 79.755n 0.0v 84.745n 0.0v 84.755n 0.0v 89.745n 0.0v 89.755n 0.0v 94.745n 0.0v 94.755n 0.0v 99.745n 0.0v 99.755n 0.0v 104.745n 0.0v 104.755n 0.0v 109.745n 0.0v 109.755n 0.0v 114.745n 0.0v 114.755n 0.0v 119.745n 0.0v 119.755n 0.0v 124.745n 0.0v 124.755n 0.0v 129.745n 0.0v 129.755n 0.0v 134.745n 0.0v 134.755n 1.1v 139.745n 1.1v 139.755n 1.1v 144.745n 1.1v 144.755n 1.1v 149.745n 1.1v 149.755n 1.1v 154.745n 1.1v 154.755n 1.1v 159.745n 1.1v 159.755n 1.1v 164.745n 1.1v 164.755n 1.1v 169.745n 1.1v 169.755n 1.1v 174.745n 1.1v 174.755n 1.1v 179.745n 1.1v 179.755n 1.1v 184.745n 1.1v 184.755n 1.1v 189.745n 1.1v 189.755n 1.1v 194.745n 1.1v 194.755n 1.1v 199.745n 1.1v 199.755n 1.1v 204.745n 1.1v 204.755n 1.1v 209.745n 1.1v 209.755n 1.1v 214.745n 1.1v 214.755n 1.1v 219.745n 1.1v 219.755n 1.1v 224.745n 1.1v 224.755n 1.1v 229.745n 1.1v 229.755n 1.1v 234.745n 1.1v 234.755n 1.1v 239.745n 1.1v 239.755n 1.1v 244.745n 1.1v 244.755n 1.1v 249.745n 1.1v 249.755n 1.1v 254.745n 1.1v 254.755n 1.1v 259.745n 1.1v 259.755n 1.1v 264.745n 1.1v 264.755n 1.1v 269.745n 1.1v 269.755n 0.0v 274.745n 0.0v 274.755n 0.0v 279.745n 0.0v 279.755n 0.0v 284.745n 0.0v 284.755n 0.0v 289.745n 0.0v 289.755n 0.0v 294.745n 0.0v 294.755n 0.0v 299.745n 0.0v 299.755n 0.0v 304.745n 0.0v 304.755n 0.0v 309.745n 0.0v 309.755n 0.0v 314.745n 0.0v 314.755n 0.0v 319.745n 0.0v 319.755n 0.0v 324.745n 0.0v 324.755n 0.0v 329.745n 0.0v 329.755n 0.0v 334.745n 0.0v 334.755n 0.0v 339.745n 0.0v 339.755n 0.0v 344.745n 0.0v 344.755n 0.0v 349.745n 0.0v 349.755n 0.0v 354.745n 0.0v 354.755n 1.1v 359.745n 1.1v 359.755n 1.1v 364.745n 1.1v 364.755n 1.1v 369.745n 1.1v 369.755n 1.1v 374.745n 1.1v 374.755n 1.1v 379.745n 1.1v 379.755n 0.0v 384.745n 0.0v 384.755n 0.0v 389.745n 0.0v 389.755n 0.0v 394.745n 0.0v 394.755n 0.0v 399.745n 0.0v 399.755n 0.0v 404.745n 0.0v 404.755n 0.0v 409.745n 0.0v 409.755n 0.0v 414.745n 0.0v 414.755n 0.0v 419.745n 0.0v 419.755n 0.0v 424.745n 0.0v 424.755n 0.0v 429.745n 0.0v 429.755n 0.0v 434.745n 0.0v 434.755n 0.0v 439.745n 0.0v 439.755n 0.0v 444.745n 0.0v 444.755n 0.0v 449.745n 0.0v 449.755n 0.0v 454.745n 0.0v 454.755n 0.0v 459.745n 0.0v 459.755n 0.0v 464.745n 0.0v 464.755n 0.0v 469.745n 0.0v 469.755n 1.1v 474.745n 1.1v 474.755n 0.0v 479.745n 0.0v 479.755n 0.0v 484.745n 0.0v 484.755n 0.0v 489.745n 0.0v 489.755n 0.0v 494.745n 0.0v 494.755n 0.0v 499.745n 0.0v 499.755n 0.0v 504.745n 0.0v 504.755n 0.0v 509.745n 0.0v 509.755n 0.0v 514.745n 0.0v 514.755n 0.0v 519.745n 0.0v 519.755n 1.1v 524.745n 1.1v 524.755n 0.0v 529.745n 0.0v 529.755n 0.0v 534.745n 0.0v 534.755n 0.0v 539.745n 0.0v 539.755n 0.0v 544.745n 0.0v 544.755n 0.0v 549.745n 0.0v 549.755n 0.0v 554.745n 0.0v 554.755n 0.0v 559.745n 0.0v 559.755n 0.0v 564.745n 0.0v 564.755n 0.0v 569.745n 0.0v 569.755n 0.0v 574.745n 0.0v 574.755n 0.0v 579.745n 0.0v 579.755n 0.0v 584.745n 0.0v 584.755n 0.0v 589.745n 0.0v 589.755n 0.0v 594.745n 0.0v 594.755n 0.0v 599.745n 0.0v 599.755n 0.0v 604.745n 0.0v 604.755n 0.0v 609.745n 0.0v 609.755n 0.0v 614.745n 0.0v 614.755n 0.0v 619.745n 0.0v 619.755n 0.0v 624.745n 0.0v 624.755n 0.0v 629.745n 0.0v 629.755n 0.0v 634.745n 0.0v 634.755n 0.0v 639.745n 0.0v 639.755n 0.0v 644.745n 0.0v 644.755n 1.1v 649.745n 1.1v 649.755n 1.1v 654.745n 1.1v 654.755n 1.1v 659.745n 1.1v 659.755n 1.1v 664.745n 1.1v 664.755n 1.1v 669.745n 1.1v 669.755n 1.1v 674.745n 1.1v 674.755n 1.1v 679.745n 1.1v 679.755n 1.1v 684.745n 1.1v 684.755n 1.1v 689.745n 1.1v 689.755n 1.1v 694.745n 1.1v 694.755n 1.1v 699.745n 1.1v 699.755n 1.1v 704.745n 1.1v 704.755n 1.1v 709.745n 1.1v 709.755n 0.0v 714.745n 0.0v 714.755n 1.1v 719.745n 1.1v 719.755n 1.1v 724.745n 1.1v 724.755n 1.1v 729.745n 1.1v 729.755n 1.1v 734.745n 1.1v 734.755n 1.1v 739.745n 1.1v 739.755n 1.1v 744.745n 1.1v 744.755n 1.1v 749.745n 1.1v 749.755n 1.1v 754.745n 1.1v 754.755n 1.1v 759.745n 1.1v 759.755n 1.1v 764.745n 1.1v 764.755n 1.1v 769.745n 1.1v 769.755n 0.0v 774.745n 0.0v 774.755n 0.0v 779.745n 0.0v 779.755n 0.0v 784.745n 0.0v 784.755n 1.1v 789.745n 1.1v 789.755n 0.0v 794.745n 0.0v 794.755n 1.1v 799.745n 1.1v 799.755n 1.1v 804.745n 1.1v 804.755n 1.1v 809.745n 1.1v 809.755n 1.1v 814.745n 1.1v 814.755n 1.1v 819.745n 1.1v 819.755n 1.1v 824.745n 1.1v 824.755n 1.1v 829.745n 1.1v 829.755n 1.1v 834.745n 1.1v 834.755n 1.1v 839.745n 1.1v 839.755n 1.1v 844.745n 1.1v 844.755n 0.0v 849.745n 0.0v 849.755n 0.0v 854.745n 0.0v 854.755n 0.0v 859.745n 0.0v 859.755n 0.0v 864.745n 0.0v 864.755n 0.0v 869.745n 0.0v 869.755n 0.0v 874.745n 0.0v 874.755n 0.0v 879.745n 0.0v 879.755n 0.0v 884.745n 0.0v 884.755n 0.0v 889.745n 0.0v 889.755n 1.1v 894.745n 1.1v 894.755n 1.1v 899.745n 1.1v 899.755n 1.1v 904.745n 1.1v 904.755n 1.1v 909.745n 1.1v 909.755n 0.0v 914.745n 0.0v 914.755n 0.0v 919.745n 0.0v 919.755n 0.0v 924.745n 0.0v 924.755n 0.0v 929.745n 0.0v 929.755n 0.0v 934.745n 0.0v 934.755n 0.0v 939.745n 0.0v 939.755n 0.0v 944.745n 0.0v 944.755n 0.0v 949.745n 0.0v 949.755n 0.0v 954.745n 0.0v 954.755n 0.0v 959.745n 0.0v 959.755n 0.0v 964.745n 0.0v 964.755n 0.0v 969.745n 0.0v 969.755n 0.0v 974.745n 0.0v 974.755n 0.0v 979.745n 0.0v 979.755n 0.0v 984.745n 0.0v 984.755n 0.0v 989.745n 0.0v 989.755n 0.0v 994.745n 0.0v 994.755n 1.1v 999.745n 1.1v 999.755n 1.1v 1004.745n 1.1v 1004.755n 0.0v 1009.745n 0.0v 1009.755n 0.0v 1014.745n 0.0v 1014.755n 0.0v 1019.745n 0.0v 1019.755n 0.0v 1024.745n 0.0v 1024.755n 0.0v )
* (time, data): [(0, 0), (5, 0), (10, 0), (15, 0), (20, 0), (25, 0), (30, 1), (35, 1), (40, 1), (45, 1), (50, 1), (55, 1), (60, 1), (65, 0), (70, 0), (75, 0), (80, 1), (85, 1), (90, 1), (95, 0), (100, 0), (105, 0), (110, 1), (115, 0), (120, 0), (125, 0), (130, 1), (135, 0), (140, 1), (145, 1), (150, 1), (155, 1), (160, 1), (165, 1), (170, 1), (175, 1), (180, 1), (185, 1), (190, 1), (195, 1), (200, 1), (205, 1), (210, 1), (215, 1), (220, 1), (225, 0), (230, 0), (235, 0), (240, 0), (245, 0), (250, 0), (255, 0), (260, 0), (265, 1), (270, 0), (275, 0), (280, 0), (285, 0), (290, 0), (295, 0), (300, 0), (305, 0), (310, 0), (315, 0), (320, 0), (325, 0), (330, 0), (335, 0), (340, 0), (345, 0), (350, 0), (355, 1), (360, 1), (365, 1), (370, 1), (375, 1), (380, 0), (385, 0), (390, 0), (395, 0), (400, 0), (405, 0), (410, 0), (415, 0), (420, 1), (425, 1), (430, 1), (435, 1), (440, 1), (445, 1), (450, 1), (455, 1), (460, 1), (465, 1), (470, 1), (475, 0), (480, 0), (485, 0), (490, 0), (495, 0), (500, 0), (505, 0), (510, 0), (515, 0), (520, 1), (525, 1), (530, 1), (535, 0), (540, 0), (545, 0), (550, 0), (555, 0), (560, 0), (565, 0), (570, 0), (575, 0), (580, 0), (585, 0), (590, 0), (595, 0), (600, 0), (605, 0), (610, 0), (615, 0), (620, 1), (625, 1), (630, 1), (635, 1), (640, 1), (645, 1), (650, 1), (655, 1), (660, 0), (665, 0), (670, 0), (675, 0), (680, 1), (685, 1), (690, 1), (695, 1), (700, 1), (705, 1), (710, 1), (715, 0), (720, 0), (725, 0), (730, 0), (735, 0), (740, 1), (745, 1), (750, 1), (755, 1), (760, 1), (765, 1), (770, 0), (775, 0), (780, 0), (785, 1), (790, 0), (795, 1), (800, 1), (805, 1), (810, 1), (815, 1), (820, 1), (825, 1), (830, 1), (835, 1), (840, 1), (845, 1), (850, 1), (855, 1), (860, 0), (865, 0), (870, 0), (875, 1), (880, 1), (885, 1), (890, 0), (895, 0), (900, 1), (905, 1), (910, 0), (915, 0), (920, 0), (925, 0), (930, 0), (935, 0), (940, 0), (945, 0), (950, 0), (955, 0), (960, 0), (965, 0), (970, 0), (975, 0), (980, 0), (985, 0), (990, 0), (995, 1), (1000, 1), (1005, 0), (1010, 0), (1015, 0), (1020, 0), (1025, 0)]
Vdin0_25  din0_25  0 PWL (0n 0.0v 4.745n 0.0v 4.755n 0.0v 9.745n 0.0v 9.755n 0.0v 14.745n 0.0v 14.755n 0.0v 19.745n 0.0v 19.755n 0.0v 24.745n 0.0v 24.755n 0.0v 29.745n 0.0v 29.755n 1.1v 34.745n 1.1v 34.755n 1.1v 39.745n 1.1v 39.755n 1.1v 44.745n 1.1v 44.755n 1.1v 49.745n 1.1v 49.755n 1.1v 54.745n 1.1v 54.755n 1.1v 59.745n 1.1v 59.755n 1.1v 64.745n 1.1v 64.755n 0.0v 69.745n 0.0v 69.755n 0.0v 74.745n 0.0v 74.755n 0.0v 79.745n 0.0v 79.755n 1.1v 84.745n 1.1v 84.755n 1.1v 89.745n 1.1v 89.755n 1.1v 94.745n 1.1v 94.755n 0.0v 99.745n 0.0v 99.755n 0.0v 104.745n 0.0v 104.755n 0.0v 109.745n 0.0v 109.755n 1.1v 114.745n 1.1v 114.755n 0.0v 119.745n 0.0v 119.755n 0.0v 124.745n 0.0v 124.755n 0.0v 129.745n 0.0v 129.755n 1.1v 134.745n 1.1v 134.755n 0.0v 139.745n 0.0v 139.755n 1.1v 144.745n 1.1v 144.755n 1.1v 149.745n 1.1v 149.755n 1.1v 154.745n 1.1v 154.755n 1.1v 159.745n 1.1v 159.755n 1.1v 164.745n 1.1v 164.755n 1.1v 169.745n 1.1v 169.755n 1.1v 174.745n 1.1v 174.755n 1.1v 179.745n 1.1v 179.755n 1.1v 184.745n 1.1v 184.755n 1.1v 189.745n 1.1v 189.755n 1.1v 194.745n 1.1v 194.755n 1.1v 199.745n 1.1v 199.755n 1.1v 204.745n 1.1v 204.755n 1.1v 209.745n 1.1v 209.755n 1.1v 214.745n 1.1v 214.755n 1.1v 219.745n 1.1v 219.755n 1.1v 224.745n 1.1v 224.755n 0.0v 229.745n 0.0v 229.755n 0.0v 234.745n 0.0v 234.755n 0.0v 239.745n 0.0v 239.755n 0.0v 244.745n 0.0v 244.755n 0.0v 249.745n 0.0v 249.755n 0.0v 254.745n 0.0v 254.755n 0.0v 259.745n 0.0v 259.755n 0.0v 264.745n 0.0v 264.755n 1.1v 269.745n 1.1v 269.755n 0.0v 274.745n 0.0v 274.755n 0.0v 279.745n 0.0v 279.755n 0.0v 284.745n 0.0v 284.755n 0.0v 289.745n 0.0v 289.755n 0.0v 294.745n 0.0v 294.755n 0.0v 299.745n 0.0v 299.755n 0.0v 304.745n 0.0v 304.755n 0.0v 309.745n 0.0v 309.755n 0.0v 314.745n 0.0v 314.755n 0.0v 319.745n 0.0v 319.755n 0.0v 324.745n 0.0v 324.755n 0.0v 329.745n 0.0v 329.755n 0.0v 334.745n 0.0v 334.755n 0.0v 339.745n 0.0v 339.755n 0.0v 344.745n 0.0v 344.755n 0.0v 349.745n 0.0v 349.755n 0.0v 354.745n 0.0v 354.755n 1.1v 359.745n 1.1v 359.755n 1.1v 364.745n 1.1v 364.755n 1.1v 369.745n 1.1v 369.755n 1.1v 374.745n 1.1v 374.755n 1.1v 379.745n 1.1v 379.755n 0.0v 384.745n 0.0v 384.755n 0.0v 389.745n 0.0v 389.755n 0.0v 394.745n 0.0v 394.755n 0.0v 399.745n 0.0v 399.755n 0.0v 404.745n 0.0v 404.755n 0.0v 409.745n 0.0v 409.755n 0.0v 414.745n 0.0v 414.755n 0.0v 419.745n 0.0v 419.755n 1.1v 424.745n 1.1v 424.755n 1.1v 429.745n 1.1v 429.755n 1.1v 434.745n 1.1v 434.755n 1.1v 439.745n 1.1v 439.755n 1.1v 444.745n 1.1v 444.755n 1.1v 449.745n 1.1v 449.755n 1.1v 454.745n 1.1v 454.755n 1.1v 459.745n 1.1v 459.755n 1.1v 464.745n 1.1v 464.755n 1.1v 469.745n 1.1v 469.755n 1.1v 474.745n 1.1v 474.755n 0.0v 479.745n 0.0v 479.755n 0.0v 484.745n 0.0v 484.755n 0.0v 489.745n 0.0v 489.755n 0.0v 494.745n 0.0v 494.755n 0.0v 499.745n 0.0v 499.755n 0.0v 504.745n 0.0v 504.755n 0.0v 509.745n 0.0v 509.755n 0.0v 514.745n 0.0v 514.755n 0.0v 519.745n 0.0v 519.755n 1.1v 524.745n 1.1v 524.755n 1.1v 529.745n 1.1v 529.755n 1.1v 534.745n 1.1v 534.755n 0.0v 539.745n 0.0v 539.755n 0.0v 544.745n 0.0v 544.755n 0.0v 549.745n 0.0v 549.755n 0.0v 554.745n 0.0v 554.755n 0.0v 559.745n 0.0v 559.755n 0.0v 564.745n 0.0v 564.755n 0.0v 569.745n 0.0v 569.755n 0.0v 574.745n 0.0v 574.755n 0.0v 579.745n 0.0v 579.755n 0.0v 584.745n 0.0v 584.755n 0.0v 589.745n 0.0v 589.755n 0.0v 594.745n 0.0v 594.755n 0.0v 599.745n 0.0v 599.755n 0.0v 604.745n 0.0v 604.755n 0.0v 609.745n 0.0v 609.755n 0.0v 614.745n 0.0v 614.755n 0.0v 619.745n 0.0v 619.755n 1.1v 624.745n 1.1v 624.755n 1.1v 629.745n 1.1v 629.755n 1.1v 634.745n 1.1v 634.755n 1.1v 639.745n 1.1v 639.755n 1.1v 644.745n 1.1v 644.755n 1.1v 649.745n 1.1v 649.755n 1.1v 654.745n 1.1v 654.755n 1.1v 659.745n 1.1v 659.755n 0.0v 664.745n 0.0v 664.755n 0.0v 669.745n 0.0v 669.755n 0.0v 674.745n 0.0v 674.755n 0.0v 679.745n 0.0v 679.755n 1.1v 684.745n 1.1v 684.755n 1.1v 689.745n 1.1v 689.755n 1.1v 694.745n 1.1v 694.755n 1.1v 699.745n 1.1v 699.755n 1.1v 704.745n 1.1v 704.755n 1.1v 709.745n 1.1v 709.755n 1.1v 714.745n 1.1v 714.755n 0.0v 719.745n 0.0v 719.755n 0.0v 724.745n 0.0v 724.755n 0.0v 729.745n 0.0v 729.755n 0.0v 734.745n 0.0v 734.755n 0.0v 739.745n 0.0v 739.755n 1.1v 744.745n 1.1v 744.755n 1.1v 749.745n 1.1v 749.755n 1.1v 754.745n 1.1v 754.755n 1.1v 759.745n 1.1v 759.755n 1.1v 764.745n 1.1v 764.755n 1.1v 769.745n 1.1v 769.755n 0.0v 774.745n 0.0v 774.755n 0.0v 779.745n 0.0v 779.755n 0.0v 784.745n 0.0v 784.755n 1.1v 789.745n 1.1v 789.755n 0.0v 794.745n 0.0v 794.755n 1.1v 799.745n 1.1v 799.755n 1.1v 804.745n 1.1v 804.755n 1.1v 809.745n 1.1v 809.755n 1.1v 814.745n 1.1v 814.755n 1.1v 819.745n 1.1v 819.755n 1.1v 824.745n 1.1v 824.755n 1.1v 829.745n 1.1v 829.755n 1.1v 834.745n 1.1v 834.755n 1.1v 839.745n 1.1v 839.755n 1.1v 844.745n 1.1v 844.755n 1.1v 849.745n 1.1v 849.755n 1.1v 854.745n 1.1v 854.755n 1.1v 859.745n 1.1v 859.755n 0.0v 864.745n 0.0v 864.755n 0.0v 869.745n 0.0v 869.755n 0.0v 874.745n 0.0v 874.755n 1.1v 879.745n 1.1v 879.755n 1.1v 884.745n 1.1v 884.755n 1.1v 889.745n 1.1v 889.755n 0.0v 894.745n 0.0v 894.755n 0.0v 899.745n 0.0v 899.755n 1.1v 904.745n 1.1v 904.755n 1.1v 909.745n 1.1v 909.755n 0.0v 914.745n 0.0v 914.755n 0.0v 919.745n 0.0v 919.755n 0.0v 924.745n 0.0v 924.755n 0.0v 929.745n 0.0v 929.755n 0.0v 934.745n 0.0v 934.755n 0.0v 939.745n 0.0v 939.755n 0.0v 944.745n 0.0v 944.755n 0.0v 949.745n 0.0v 949.755n 0.0v 954.745n 0.0v 954.755n 0.0v 959.745n 0.0v 959.755n 0.0v 964.745n 0.0v 964.755n 0.0v 969.745n 0.0v 969.755n 0.0v 974.745n 0.0v 974.755n 0.0v 979.745n 0.0v 979.755n 0.0v 984.745n 0.0v 984.755n 0.0v 989.745n 0.0v 989.755n 0.0v 994.745n 0.0v 994.755n 1.1v 999.745n 1.1v 999.755n 1.1v 1004.745n 1.1v 1004.755n 0.0v 1009.745n 0.0v 1009.755n 0.0v 1014.745n 0.0v 1014.755n 0.0v 1019.745n 0.0v 1019.755n 0.0v 1024.745n 0.0v 1024.755n 0.0v )
* (time, data): [(0, 0), (5, 0), (10, 0), (15, 0), (20, 0), (25, 0), (30, 1), (35, 1), (40, 1), (45, 1), (50, 1), (55, 1), (60, 1), (65, 0), (70, 0), (75, 0), (80, 0), (85, 0), (90, 0), (95, 0), (100, 0), (105, 0), (110, 0), (115, 0), (120, 0), (125, 0), (130, 1), (135, 0), (140, 1), (145, 1), (150, 1), (155, 1), (160, 1), (165, 1), (170, 1), (175, 1), (180, 1), (185, 1), (190, 1), (195, 1), (200, 1), (205, 1), (210, 1), (215, 1), (220, 1), (225, 0), (230, 0), (235, 0), (240, 0), (245, 0), (250, 0), (255, 0), (260, 0), (265, 1), (270, 1), (275, 1), (280, 1), (285, 1), (290, 1), (295, 1), (300, 1), (305, 1), (310, 1), (315, 1), (320, 1), (325, 1), (330, 1), (335, 1), (340, 1), (345, 1), (350, 1), (355, 1), (360, 1), (365, 1), (370, 1), (375, 1), (380, 0), (385, 0), (390, 0), (395, 0), (400, 0), (405, 0), (410, 0), (415, 0), (420, 0), (425, 0), (430, 0), (435, 0), (440, 0), (445, 0), (450, 0), (455, 0), (460, 0), (465, 0), (470, 0), (475, 1), (480, 1), (485, 1), (490, 1), (495, 0), (500, 0), (505, 0), (510, 0), (515, 0), (520, 1), (525, 1), (530, 1), (535, 0), (540, 0), (545, 0), (550, 0), (555, 0), (560, 0), (565, 0), (570, 0), (575, 0), (580, 0), (585, 0), (590, 0), (595, 0), (600, 0), (605, 0), (610, 0), (615, 0), (620, 1), (625, 1), (630, 1), (635, 1), (640, 1), (645, 1), (650, 1), (655, 1), (660, 1), (665, 0), (670, 0), (675, 0), (680, 0), (685, 0), (690, 0), (695, 0), (700, 0), (705, 0), (710, 0), (715, 1), (720, 1), (725, 1), (730, 1), (735, 1), (740, 1), (745, 1), (750, 1), (755, 1), (760, 1), (765, 1), (770, 1), (775, 1), (780, 1), (785, 1), (790, 0), (795, 1), (800, 1), (805, 1), (810, 1), (815, 1), (820, 1), (825, 1), (830, 1), (835, 1), (840, 1), (845, 1), (850, 1), (855, 1), (860, 1), (865, 1), (870, 1), (875, 1), (880, 1), (885, 1), (890, 1), (895, 1), (900, 1), (905, 1), (910, 0), (915, 0), (920, 0), (925, 0), (930, 0), (935, 0), (940, 0), (945, 0), (950, 0), (955, 0), (960, 0), (965, 0), (970, 0), (975, 0), (980, 0), (985, 0), (990, 0), (995, 1), (1000, 1), (1005, 0), (1010, 0), (1015, 0), (1020, 0), (1025, 0)]
Vdin0_26  din0_26  0 PWL (0n 0.0v 4.745n 0.0v 4.755n 0.0v 9.745n 0.0v 9.755n 0.0v 14.745n 0.0v 14.755n 0.0v 19.745n 0.0v 19.755n 0.0v 24.745n 0.0v 24.755n 0.0v 29.745n 0.0v 29.755n 1.1v 34.745n 1.1v 34.755n 1.1v 39.745n 1.1v 39.755n 1.1v 44.745n 1.1v 44.755n 1.1v 49.745n 1.1v 49.755n 1.1v 54.745n 1.1v 54.755n 1.1v 59.745n 1.1v 59.755n 1.1v 64.745n 1.1v 64.755n 0.0v 69.745n 0.0v 69.755n 0.0v 74.745n 0.0v 74.755n 0.0v 79.745n 0.0v 79.755n 0.0v 84.745n 0.0v 84.755n 0.0v 89.745n 0.0v 89.755n 0.0v 94.745n 0.0v 94.755n 0.0v 99.745n 0.0v 99.755n 0.0v 104.745n 0.0v 104.755n 0.0v 109.745n 0.0v 109.755n 0.0v 114.745n 0.0v 114.755n 0.0v 119.745n 0.0v 119.755n 0.0v 124.745n 0.0v 124.755n 0.0v 129.745n 0.0v 129.755n 1.1v 134.745n 1.1v 134.755n 0.0v 139.745n 0.0v 139.755n 1.1v 144.745n 1.1v 144.755n 1.1v 149.745n 1.1v 149.755n 1.1v 154.745n 1.1v 154.755n 1.1v 159.745n 1.1v 159.755n 1.1v 164.745n 1.1v 164.755n 1.1v 169.745n 1.1v 169.755n 1.1v 174.745n 1.1v 174.755n 1.1v 179.745n 1.1v 179.755n 1.1v 184.745n 1.1v 184.755n 1.1v 189.745n 1.1v 189.755n 1.1v 194.745n 1.1v 194.755n 1.1v 199.745n 1.1v 199.755n 1.1v 204.745n 1.1v 204.755n 1.1v 209.745n 1.1v 209.755n 1.1v 214.745n 1.1v 214.755n 1.1v 219.745n 1.1v 219.755n 1.1v 224.745n 1.1v 224.755n 0.0v 229.745n 0.0v 229.755n 0.0v 234.745n 0.0v 234.755n 0.0v 239.745n 0.0v 239.755n 0.0v 244.745n 0.0v 244.755n 0.0v 249.745n 0.0v 249.755n 0.0v 254.745n 0.0v 254.755n 0.0v 259.745n 0.0v 259.755n 0.0v 264.745n 0.0v 264.755n 1.1v 269.745n 1.1v 269.755n 1.1v 274.745n 1.1v 274.755n 1.1v 279.745n 1.1v 279.755n 1.1v 284.745n 1.1v 284.755n 1.1v 289.745n 1.1v 289.755n 1.1v 294.745n 1.1v 294.755n 1.1v 299.745n 1.1v 299.755n 1.1v 304.745n 1.1v 304.755n 1.1v 309.745n 1.1v 309.755n 1.1v 314.745n 1.1v 314.755n 1.1v 319.745n 1.1v 319.755n 1.1v 324.745n 1.1v 324.755n 1.1v 329.745n 1.1v 329.755n 1.1v 334.745n 1.1v 334.755n 1.1v 339.745n 1.1v 339.755n 1.1v 344.745n 1.1v 344.755n 1.1v 349.745n 1.1v 349.755n 1.1v 354.745n 1.1v 354.755n 1.1v 359.745n 1.1v 359.755n 1.1v 364.745n 1.1v 364.755n 1.1v 369.745n 1.1v 369.755n 1.1v 374.745n 1.1v 374.755n 1.1v 379.745n 1.1v 379.755n 0.0v 384.745n 0.0v 384.755n 0.0v 389.745n 0.0v 389.755n 0.0v 394.745n 0.0v 394.755n 0.0v 399.745n 0.0v 399.755n 0.0v 404.745n 0.0v 404.755n 0.0v 409.745n 0.0v 409.755n 0.0v 414.745n 0.0v 414.755n 0.0v 419.745n 0.0v 419.755n 0.0v 424.745n 0.0v 424.755n 0.0v 429.745n 0.0v 429.755n 0.0v 434.745n 0.0v 434.755n 0.0v 439.745n 0.0v 439.755n 0.0v 444.745n 0.0v 444.755n 0.0v 449.745n 0.0v 449.755n 0.0v 454.745n 0.0v 454.755n 0.0v 459.745n 0.0v 459.755n 0.0v 464.745n 0.0v 464.755n 0.0v 469.745n 0.0v 469.755n 0.0v 474.745n 0.0v 474.755n 1.1v 479.745n 1.1v 479.755n 1.1v 484.745n 1.1v 484.755n 1.1v 489.745n 1.1v 489.755n 1.1v 494.745n 1.1v 494.755n 0.0v 499.745n 0.0v 499.755n 0.0v 504.745n 0.0v 504.755n 0.0v 509.745n 0.0v 509.755n 0.0v 514.745n 0.0v 514.755n 0.0v 519.745n 0.0v 519.755n 1.1v 524.745n 1.1v 524.755n 1.1v 529.745n 1.1v 529.755n 1.1v 534.745n 1.1v 534.755n 0.0v 539.745n 0.0v 539.755n 0.0v 544.745n 0.0v 544.755n 0.0v 549.745n 0.0v 549.755n 0.0v 554.745n 0.0v 554.755n 0.0v 559.745n 0.0v 559.755n 0.0v 564.745n 0.0v 564.755n 0.0v 569.745n 0.0v 569.755n 0.0v 574.745n 0.0v 574.755n 0.0v 579.745n 0.0v 579.755n 0.0v 584.745n 0.0v 584.755n 0.0v 589.745n 0.0v 589.755n 0.0v 594.745n 0.0v 594.755n 0.0v 599.745n 0.0v 599.755n 0.0v 604.745n 0.0v 604.755n 0.0v 609.745n 0.0v 609.755n 0.0v 614.745n 0.0v 614.755n 0.0v 619.745n 0.0v 619.755n 1.1v 624.745n 1.1v 624.755n 1.1v 629.745n 1.1v 629.755n 1.1v 634.745n 1.1v 634.755n 1.1v 639.745n 1.1v 639.755n 1.1v 644.745n 1.1v 644.755n 1.1v 649.745n 1.1v 649.755n 1.1v 654.745n 1.1v 654.755n 1.1v 659.745n 1.1v 659.755n 1.1v 664.745n 1.1v 664.755n 0.0v 669.745n 0.0v 669.755n 0.0v 674.745n 0.0v 674.755n 0.0v 679.745n 0.0v 679.755n 0.0v 684.745n 0.0v 684.755n 0.0v 689.745n 0.0v 689.755n 0.0v 694.745n 0.0v 694.755n 0.0v 699.745n 0.0v 699.755n 0.0v 704.745n 0.0v 704.755n 0.0v 709.745n 0.0v 709.755n 0.0v 714.745n 0.0v 714.755n 1.1v 719.745n 1.1v 719.755n 1.1v 724.745n 1.1v 724.755n 1.1v 729.745n 1.1v 729.755n 1.1v 734.745n 1.1v 734.755n 1.1v 739.745n 1.1v 739.755n 1.1v 744.745n 1.1v 744.755n 1.1v 749.745n 1.1v 749.755n 1.1v 754.745n 1.1v 754.755n 1.1v 759.745n 1.1v 759.755n 1.1v 764.745n 1.1v 764.755n 1.1v 769.745n 1.1v 769.755n 1.1v 774.745n 1.1v 774.755n 1.1v 779.745n 1.1v 779.755n 1.1v 784.745n 1.1v 784.755n 1.1v 789.745n 1.1v 789.755n 0.0v 794.745n 0.0v 794.755n 1.1v 799.745n 1.1v 799.755n 1.1v 804.745n 1.1v 804.755n 1.1v 809.745n 1.1v 809.755n 1.1v 814.745n 1.1v 814.755n 1.1v 819.745n 1.1v 819.755n 1.1v 824.745n 1.1v 824.755n 1.1v 829.745n 1.1v 829.755n 1.1v 834.745n 1.1v 834.755n 1.1v 839.745n 1.1v 839.755n 1.1v 844.745n 1.1v 844.755n 1.1v 849.745n 1.1v 849.755n 1.1v 854.745n 1.1v 854.755n 1.1v 859.745n 1.1v 859.755n 1.1v 864.745n 1.1v 864.755n 1.1v 869.745n 1.1v 869.755n 1.1v 874.745n 1.1v 874.755n 1.1v 879.745n 1.1v 879.755n 1.1v 884.745n 1.1v 884.755n 1.1v 889.745n 1.1v 889.755n 1.1v 894.745n 1.1v 894.755n 1.1v 899.745n 1.1v 899.755n 1.1v 904.745n 1.1v 904.755n 1.1v 909.745n 1.1v 909.755n 0.0v 914.745n 0.0v 914.755n 0.0v 919.745n 0.0v 919.755n 0.0v 924.745n 0.0v 924.755n 0.0v 929.745n 0.0v 929.755n 0.0v 934.745n 0.0v 934.755n 0.0v 939.745n 0.0v 939.755n 0.0v 944.745n 0.0v 944.755n 0.0v 949.745n 0.0v 949.755n 0.0v 954.745n 0.0v 954.755n 0.0v 959.745n 0.0v 959.755n 0.0v 964.745n 0.0v 964.755n 0.0v 969.745n 0.0v 969.755n 0.0v 974.745n 0.0v 974.755n 0.0v 979.745n 0.0v 979.755n 0.0v 984.745n 0.0v 984.755n 0.0v 989.745n 0.0v 989.755n 0.0v 994.745n 0.0v 994.755n 1.1v 999.745n 1.1v 999.755n 1.1v 1004.745n 1.1v 1004.755n 0.0v 1009.745n 0.0v 1009.755n 0.0v 1014.745n 0.0v 1014.755n 0.0v 1019.745n 0.0v 1019.755n 0.0v 1024.745n 0.0v 1024.755n 0.0v )
* (time, data): [(0, 0), (5, 1), (10, 0), (15, 1), (20, 1), (25, 1), (30, 0), (35, 1), (40, 1), (45, 1), (50, 1), (55, 1), (60, 0), (65, 0), (70, 0), (75, 0), (80, 0), (85, 0), (90, 0), (95, 1), (100, 1), (105, 1), (110, 1), (115, 0), (120, 0), (125, 0), (130, 0), (135, 0), (140, 1), (145, 1), (150, 0), (155, 0), (160, 0), (165, 0), (170, 0), (175, 0), (180, 0), (185, 0), (190, 0), (195, 0), (200, 0), (205, 0), (210, 0), (215, 0), (220, 0), (225, 1), (230, 1), (235, 1), (240, 1), (245, 1), (250, 1), (255, 1), (260, 1), (265, 1), (270, 1), (275, 1), (280, 1), (285, 1), (290, 1), (295, 1), (300, 1), (305, 1), (310, 1), (315, 1), (320, 1), (325, 1), (330, 1), (335, 1), (340, 1), (345, 1), (350, 1), (355, 1), (360, 1), (365, 1), (370, 1), (375, 1), (380, 1), (385, 1), (390, 1), (395, 1), (400, 1), (405, 1), (410, 1), (415, 1), (420, 0), (425, 0), (430, 0), (435, 0), (440, 0), (445, 0), (450, 0), (455, 0), (460, 0), (465, 0), (470, 0), (475, 0), (480, 0), (485, 0), (490, 0), (495, 1), (500, 1), (505, 1), (510, 1), (515, 1), (520, 0), (525, 1), (530, 1), (535, 0), (540, 0), (545, 0), (550, 0), (555, 0), (560, 0), (565, 0), (570, 0), (575, 0), (580, 0), (585, 0), (590, 0), (595, 0), (600, 0), (605, 0), (610, 0), (615, 0), (620, 1), (625, 1), (630, 1), (635, 1), (640, 1), (645, 0), (650, 0), (655, 0), (660, 1), (665, 1), (670, 1), (675, 0), (680, 0), (685, 0), (690, 0), (695, 0), (700, 0), (705, 0), (710, 0), (715, 0), (720, 0), (725, 0), (730, 0), (735, 0), (740, 1), (745, 1), (750, 1), (755, 1), (760, 1), (765, 1), (770, 0), (775, 0), (780, 0), (785, 1), (790, 0), (795, 0), (800, 0), (805, 0), (810, 0), (815, 0), (820, 0), (825, 0), (830, 0), (835, 0), (840, 0), (845, 0), (850, 0), (855, 0), (860, 0), (865, 1), (870, 1), (875, 1), (880, 1), (885, 1), (890, 0), (895, 0), (900, 0), (905, 0), (910, 1), (915, 1), (920, 1), (925, 1), (930, 1), (935, 1), (940, 1), (945, 1), (950, 1), (955, 1), (960, 1), (965, 1), (970, 1), (975, 1), (980, 1), (985, 1), (990, 1), (995, 0), (1000, 0), (1005, 0), (1010, 0), (1015, 0), (1020, 0), (1025, 0)]
Vdin0_27  din0_27  0 PWL (0n 0.0v 4.745n 0.0v 4.755n 1.1v 9.745n 1.1v 9.755n 0.0v 14.745n 0.0v 14.755n 1.1v 19.745n 1.1v 19.755n 1.1v 24.745n 1.1v 24.755n 1.1v 29.745n 1.1v 29.755n 0.0v 34.745n 0.0v 34.755n 1.1v 39.745n 1.1v 39.755n 1.1v 44.745n 1.1v 44.755n 1.1v 49.745n 1.1v 49.755n 1.1v 54.745n 1.1v 54.755n 1.1v 59.745n 1.1v 59.755n 0.0v 64.745n 0.0v 64.755n 0.0v 69.745n 0.0v 69.755n 0.0v 74.745n 0.0v 74.755n 0.0v 79.745n 0.0v 79.755n 0.0v 84.745n 0.0v 84.755n 0.0v 89.745n 0.0v 89.755n 0.0v 94.745n 0.0v 94.755n 1.1v 99.745n 1.1v 99.755n 1.1v 104.745n 1.1v 104.755n 1.1v 109.745n 1.1v 109.755n 1.1v 114.745n 1.1v 114.755n 0.0v 119.745n 0.0v 119.755n 0.0v 124.745n 0.0v 124.755n 0.0v 129.745n 0.0v 129.755n 0.0v 134.745n 0.0v 134.755n 0.0v 139.745n 0.0v 139.755n 1.1v 144.745n 1.1v 144.755n 1.1v 149.745n 1.1v 149.755n 0.0v 154.745n 0.0v 154.755n 0.0v 159.745n 0.0v 159.755n 0.0v 164.745n 0.0v 164.755n 0.0v 169.745n 0.0v 169.755n 0.0v 174.745n 0.0v 174.755n 0.0v 179.745n 0.0v 179.755n 0.0v 184.745n 0.0v 184.755n 0.0v 189.745n 0.0v 189.755n 0.0v 194.745n 0.0v 194.755n 0.0v 199.745n 0.0v 199.755n 0.0v 204.745n 0.0v 204.755n 0.0v 209.745n 0.0v 209.755n 0.0v 214.745n 0.0v 214.755n 0.0v 219.745n 0.0v 219.755n 0.0v 224.745n 0.0v 224.755n 1.1v 229.745n 1.1v 229.755n 1.1v 234.745n 1.1v 234.755n 1.1v 239.745n 1.1v 239.755n 1.1v 244.745n 1.1v 244.755n 1.1v 249.745n 1.1v 249.755n 1.1v 254.745n 1.1v 254.755n 1.1v 259.745n 1.1v 259.755n 1.1v 264.745n 1.1v 264.755n 1.1v 269.745n 1.1v 269.755n 1.1v 274.745n 1.1v 274.755n 1.1v 279.745n 1.1v 279.755n 1.1v 284.745n 1.1v 284.755n 1.1v 289.745n 1.1v 289.755n 1.1v 294.745n 1.1v 294.755n 1.1v 299.745n 1.1v 299.755n 1.1v 304.745n 1.1v 304.755n 1.1v 309.745n 1.1v 309.755n 1.1v 314.745n 1.1v 314.755n 1.1v 319.745n 1.1v 319.755n 1.1v 324.745n 1.1v 324.755n 1.1v 329.745n 1.1v 329.755n 1.1v 334.745n 1.1v 334.755n 1.1v 339.745n 1.1v 339.755n 1.1v 344.745n 1.1v 344.755n 1.1v 349.745n 1.1v 349.755n 1.1v 354.745n 1.1v 354.755n 1.1v 359.745n 1.1v 359.755n 1.1v 364.745n 1.1v 364.755n 1.1v 369.745n 1.1v 369.755n 1.1v 374.745n 1.1v 374.755n 1.1v 379.745n 1.1v 379.755n 1.1v 384.745n 1.1v 384.755n 1.1v 389.745n 1.1v 389.755n 1.1v 394.745n 1.1v 394.755n 1.1v 399.745n 1.1v 399.755n 1.1v 404.745n 1.1v 404.755n 1.1v 409.745n 1.1v 409.755n 1.1v 414.745n 1.1v 414.755n 1.1v 419.745n 1.1v 419.755n 0.0v 424.745n 0.0v 424.755n 0.0v 429.745n 0.0v 429.755n 0.0v 434.745n 0.0v 434.755n 0.0v 439.745n 0.0v 439.755n 0.0v 444.745n 0.0v 444.755n 0.0v 449.745n 0.0v 449.755n 0.0v 454.745n 0.0v 454.755n 0.0v 459.745n 0.0v 459.755n 0.0v 464.745n 0.0v 464.755n 0.0v 469.745n 0.0v 469.755n 0.0v 474.745n 0.0v 474.755n 0.0v 479.745n 0.0v 479.755n 0.0v 484.745n 0.0v 484.755n 0.0v 489.745n 0.0v 489.755n 0.0v 494.745n 0.0v 494.755n 1.1v 499.745n 1.1v 499.755n 1.1v 504.745n 1.1v 504.755n 1.1v 509.745n 1.1v 509.755n 1.1v 514.745n 1.1v 514.755n 1.1v 519.745n 1.1v 519.755n 0.0v 524.745n 0.0v 524.755n 1.1v 529.745n 1.1v 529.755n 1.1v 534.745n 1.1v 534.755n 0.0v 539.745n 0.0v 539.755n 0.0v 544.745n 0.0v 544.755n 0.0v 549.745n 0.0v 549.755n 0.0v 554.745n 0.0v 554.755n 0.0v 559.745n 0.0v 559.755n 0.0v 564.745n 0.0v 564.755n 0.0v 569.745n 0.0v 569.755n 0.0v 574.745n 0.0v 574.755n 0.0v 579.745n 0.0v 579.755n 0.0v 584.745n 0.0v 584.755n 0.0v 589.745n 0.0v 589.755n 0.0v 594.745n 0.0v 594.755n 0.0v 599.745n 0.0v 599.755n 0.0v 604.745n 0.0v 604.755n 0.0v 609.745n 0.0v 609.755n 0.0v 614.745n 0.0v 614.755n 0.0v 619.745n 0.0v 619.755n 1.1v 624.745n 1.1v 624.755n 1.1v 629.745n 1.1v 629.755n 1.1v 634.745n 1.1v 634.755n 1.1v 639.745n 1.1v 639.755n 1.1v 644.745n 1.1v 644.755n 0.0v 649.745n 0.0v 649.755n 0.0v 654.745n 0.0v 654.755n 0.0v 659.745n 0.0v 659.755n 1.1v 664.745n 1.1v 664.755n 1.1v 669.745n 1.1v 669.755n 1.1v 674.745n 1.1v 674.755n 0.0v 679.745n 0.0v 679.755n 0.0v 684.745n 0.0v 684.755n 0.0v 689.745n 0.0v 689.755n 0.0v 694.745n 0.0v 694.755n 0.0v 699.745n 0.0v 699.755n 0.0v 704.745n 0.0v 704.755n 0.0v 709.745n 0.0v 709.755n 0.0v 714.745n 0.0v 714.755n 0.0v 719.745n 0.0v 719.755n 0.0v 724.745n 0.0v 724.755n 0.0v 729.745n 0.0v 729.755n 0.0v 734.745n 0.0v 734.755n 0.0v 739.745n 0.0v 739.755n 1.1v 744.745n 1.1v 744.755n 1.1v 749.745n 1.1v 749.755n 1.1v 754.745n 1.1v 754.755n 1.1v 759.745n 1.1v 759.755n 1.1v 764.745n 1.1v 764.755n 1.1v 769.745n 1.1v 769.755n 0.0v 774.745n 0.0v 774.755n 0.0v 779.745n 0.0v 779.755n 0.0v 784.745n 0.0v 784.755n 1.1v 789.745n 1.1v 789.755n 0.0v 794.745n 0.0v 794.755n 0.0v 799.745n 0.0v 799.755n 0.0v 804.745n 0.0v 804.755n 0.0v 809.745n 0.0v 809.755n 0.0v 814.745n 0.0v 814.755n 0.0v 819.745n 0.0v 819.755n 0.0v 824.745n 0.0v 824.755n 0.0v 829.745n 0.0v 829.755n 0.0v 834.745n 0.0v 834.755n 0.0v 839.745n 0.0v 839.755n 0.0v 844.745n 0.0v 844.755n 0.0v 849.745n 0.0v 849.755n 0.0v 854.745n 0.0v 854.755n 0.0v 859.745n 0.0v 859.755n 0.0v 864.745n 0.0v 864.755n 1.1v 869.745n 1.1v 869.755n 1.1v 874.745n 1.1v 874.755n 1.1v 879.745n 1.1v 879.755n 1.1v 884.745n 1.1v 884.755n 1.1v 889.745n 1.1v 889.755n 0.0v 894.745n 0.0v 894.755n 0.0v 899.745n 0.0v 899.755n 0.0v 904.745n 0.0v 904.755n 0.0v 909.745n 0.0v 909.755n 1.1v 914.745n 1.1v 914.755n 1.1v 919.745n 1.1v 919.755n 1.1v 924.745n 1.1v 924.755n 1.1v 929.745n 1.1v 929.755n 1.1v 934.745n 1.1v 934.755n 1.1v 939.745n 1.1v 939.755n 1.1v 944.745n 1.1v 944.755n 1.1v 949.745n 1.1v 949.755n 1.1v 954.745n 1.1v 954.755n 1.1v 959.745n 1.1v 959.755n 1.1v 964.745n 1.1v 964.755n 1.1v 969.745n 1.1v 969.755n 1.1v 974.745n 1.1v 974.755n 1.1v 979.745n 1.1v 979.755n 1.1v 984.745n 1.1v 984.755n 1.1v 989.745n 1.1v 989.755n 1.1v 994.745n 1.1v 994.755n 0.0v 999.745n 0.0v 999.755n 0.0v 1004.745n 0.0v 1004.755n 0.0v 1009.745n 0.0v 1009.755n 0.0v 1014.745n 0.0v 1014.755n 0.0v 1019.745n 0.0v 1019.755n 0.0v 1024.745n 0.0v 1024.755n 0.0v )
* (time, data): [(0, 0), (5, 1), (10, 0), (15, 1), (20, 1), (25, 1), (30, 0), (35, 1), (40, 1), (45, 1), (50, 1), (55, 1), (60, 0), (65, 0), (70, 0), (75, 0), (80, 0), (85, 0), (90, 0), (95, 0), (100, 0), (105, 0), (110, 0), (115, 0), (120, 0), (125, 0), (130, 1), (135, 0), (140, 1), (145, 1), (150, 1), (155, 0), (160, 0), (165, 0), (170, 0), (175, 0), (180, 0), (185, 0), (190, 0), (195, 0), (200, 0), (205, 0), (210, 0), (215, 0), (220, 0), (225, 1), (230, 1), (235, 1), (240, 1), (245, 1), (250, 1), (255, 1), (260, 1), (265, 0), (270, 0), (275, 0), (280, 0), (285, 0), (290, 0), (295, 0), (300, 0), (305, 0), (310, 0), (315, 0), (320, 0), (325, 0), (330, 0), (335, 0), (340, 0), (345, 0), (350, 0), (355, 1), (360, 1), (365, 1), (370, 1), (375, 1), (380, 0), (385, 0), (390, 0), (395, 0), (400, 0), (405, 0), (410, 0), (415, 0), (420, 0), (425, 0), (430, 0), (435, 0), (440, 0), (445, 0), (450, 0), (455, 0), (460, 0), (465, 0), (470, 1), (475, 0), (480, 0), (485, 0), (490, 0), (495, 1), (500, 1), (505, 1), (510, 1), (515, 1), (520, 1), (525, 0), (530, 0), (535, 0), (540, 0), (545, 0), (550, 0), (555, 0), (560, 0), (565, 0), (570, 0), (575, 0), (580, 0), (585, 0), (590, 0), (595, 0), (600, 0), (605, 0), (610, 0), (615, 0), (620, 1), (625, 1), (630, 1), (635, 1), (640, 1), (645, 1), (650, 1), (655, 1), (660, 1), (665, 0), (670, 0), (675, 1), (680, 0), (685, 0), (690, 0), (695, 0), (700, 0), (705, 0), (710, 1), (715, 0), (720, 0), (725, 0), (730, 0), (735, 0), (740, 1), (745, 1), (750, 1), (755, 1), (760, 1), (765, 1), (770, 1), (775, 1), (780, 1), (785, 1), (790, 0), (795, 0), (800, 0), (805, 0), (810, 0), (815, 0), (820, 0), (825, 0), (830, 0), (835, 0), (840, 0), (845, 1), (850, 1), (855, 1), (860, 1), (865, 1), (870, 1), (875, 1), (880, 1), (885, 1), (890, 0), (895, 0), (900, 0), (905, 0), (910, 1), (915, 1), (920, 1), (925, 1), (930, 1), (935, 1), (940, 1), (945, 1), (950, 1), (955, 1), (960, 1), (965, 1), (970, 1), (975, 1), (980, 1), (985, 1), (990, 1), (995, 1), (1000, 1), (1005, 0), (1010, 0), (1015, 0), (1020, 0), (1025, 0)]
Vdin0_28  din0_28  0 PWL (0n 0.0v 4.745n 0.0v 4.755n 1.1v 9.745n 1.1v 9.755n 0.0v 14.745n 0.0v 14.755n 1.1v 19.745n 1.1v 19.755n 1.1v 24.745n 1.1v 24.755n 1.1v 29.745n 1.1v 29.755n 0.0v 34.745n 0.0v 34.755n 1.1v 39.745n 1.1v 39.755n 1.1v 44.745n 1.1v 44.755n 1.1v 49.745n 1.1v 49.755n 1.1v 54.745n 1.1v 54.755n 1.1v 59.745n 1.1v 59.755n 0.0v 64.745n 0.0v 64.755n 0.0v 69.745n 0.0v 69.755n 0.0v 74.745n 0.0v 74.755n 0.0v 79.745n 0.0v 79.755n 0.0v 84.745n 0.0v 84.755n 0.0v 89.745n 0.0v 89.755n 0.0v 94.745n 0.0v 94.755n 0.0v 99.745n 0.0v 99.755n 0.0v 104.745n 0.0v 104.755n 0.0v 109.745n 0.0v 109.755n 0.0v 114.745n 0.0v 114.755n 0.0v 119.745n 0.0v 119.755n 0.0v 124.745n 0.0v 124.755n 0.0v 129.745n 0.0v 129.755n 1.1v 134.745n 1.1v 134.755n 0.0v 139.745n 0.0v 139.755n 1.1v 144.745n 1.1v 144.755n 1.1v 149.745n 1.1v 149.755n 1.1v 154.745n 1.1v 154.755n 0.0v 159.745n 0.0v 159.755n 0.0v 164.745n 0.0v 164.755n 0.0v 169.745n 0.0v 169.755n 0.0v 174.745n 0.0v 174.755n 0.0v 179.745n 0.0v 179.755n 0.0v 184.745n 0.0v 184.755n 0.0v 189.745n 0.0v 189.755n 0.0v 194.745n 0.0v 194.755n 0.0v 199.745n 0.0v 199.755n 0.0v 204.745n 0.0v 204.755n 0.0v 209.745n 0.0v 209.755n 0.0v 214.745n 0.0v 214.755n 0.0v 219.745n 0.0v 219.755n 0.0v 224.745n 0.0v 224.755n 1.1v 229.745n 1.1v 229.755n 1.1v 234.745n 1.1v 234.755n 1.1v 239.745n 1.1v 239.755n 1.1v 244.745n 1.1v 244.755n 1.1v 249.745n 1.1v 249.755n 1.1v 254.745n 1.1v 254.755n 1.1v 259.745n 1.1v 259.755n 1.1v 264.745n 1.1v 264.755n 0.0v 269.745n 0.0v 269.755n 0.0v 274.745n 0.0v 274.755n 0.0v 279.745n 0.0v 279.755n 0.0v 284.745n 0.0v 284.755n 0.0v 289.745n 0.0v 289.755n 0.0v 294.745n 0.0v 294.755n 0.0v 299.745n 0.0v 299.755n 0.0v 304.745n 0.0v 304.755n 0.0v 309.745n 0.0v 309.755n 0.0v 314.745n 0.0v 314.755n 0.0v 319.745n 0.0v 319.755n 0.0v 324.745n 0.0v 324.755n 0.0v 329.745n 0.0v 329.755n 0.0v 334.745n 0.0v 334.755n 0.0v 339.745n 0.0v 339.755n 0.0v 344.745n 0.0v 344.755n 0.0v 349.745n 0.0v 349.755n 0.0v 354.745n 0.0v 354.755n 1.1v 359.745n 1.1v 359.755n 1.1v 364.745n 1.1v 364.755n 1.1v 369.745n 1.1v 369.755n 1.1v 374.745n 1.1v 374.755n 1.1v 379.745n 1.1v 379.755n 0.0v 384.745n 0.0v 384.755n 0.0v 389.745n 0.0v 389.755n 0.0v 394.745n 0.0v 394.755n 0.0v 399.745n 0.0v 399.755n 0.0v 404.745n 0.0v 404.755n 0.0v 409.745n 0.0v 409.755n 0.0v 414.745n 0.0v 414.755n 0.0v 419.745n 0.0v 419.755n 0.0v 424.745n 0.0v 424.755n 0.0v 429.745n 0.0v 429.755n 0.0v 434.745n 0.0v 434.755n 0.0v 439.745n 0.0v 439.755n 0.0v 444.745n 0.0v 444.755n 0.0v 449.745n 0.0v 449.755n 0.0v 454.745n 0.0v 454.755n 0.0v 459.745n 0.0v 459.755n 0.0v 464.745n 0.0v 464.755n 0.0v 469.745n 0.0v 469.755n 1.1v 474.745n 1.1v 474.755n 0.0v 479.745n 0.0v 479.755n 0.0v 484.745n 0.0v 484.755n 0.0v 489.745n 0.0v 489.755n 0.0v 494.745n 0.0v 494.755n 1.1v 499.745n 1.1v 499.755n 1.1v 504.745n 1.1v 504.755n 1.1v 509.745n 1.1v 509.755n 1.1v 514.745n 1.1v 514.755n 1.1v 519.745n 1.1v 519.755n 1.1v 524.745n 1.1v 524.755n 0.0v 529.745n 0.0v 529.755n 0.0v 534.745n 0.0v 534.755n 0.0v 539.745n 0.0v 539.755n 0.0v 544.745n 0.0v 544.755n 0.0v 549.745n 0.0v 549.755n 0.0v 554.745n 0.0v 554.755n 0.0v 559.745n 0.0v 559.755n 0.0v 564.745n 0.0v 564.755n 0.0v 569.745n 0.0v 569.755n 0.0v 574.745n 0.0v 574.755n 0.0v 579.745n 0.0v 579.755n 0.0v 584.745n 0.0v 584.755n 0.0v 589.745n 0.0v 589.755n 0.0v 594.745n 0.0v 594.755n 0.0v 599.745n 0.0v 599.755n 0.0v 604.745n 0.0v 604.755n 0.0v 609.745n 0.0v 609.755n 0.0v 614.745n 0.0v 614.755n 0.0v 619.745n 0.0v 619.755n 1.1v 624.745n 1.1v 624.755n 1.1v 629.745n 1.1v 629.755n 1.1v 634.745n 1.1v 634.755n 1.1v 639.745n 1.1v 639.755n 1.1v 644.745n 1.1v 644.755n 1.1v 649.745n 1.1v 649.755n 1.1v 654.745n 1.1v 654.755n 1.1v 659.745n 1.1v 659.755n 1.1v 664.745n 1.1v 664.755n 0.0v 669.745n 0.0v 669.755n 0.0v 674.745n 0.0v 674.755n 1.1v 679.745n 1.1v 679.755n 0.0v 684.745n 0.0v 684.755n 0.0v 689.745n 0.0v 689.755n 0.0v 694.745n 0.0v 694.755n 0.0v 699.745n 0.0v 699.755n 0.0v 704.745n 0.0v 704.755n 0.0v 709.745n 0.0v 709.755n 1.1v 714.745n 1.1v 714.755n 0.0v 719.745n 0.0v 719.755n 0.0v 724.745n 0.0v 724.755n 0.0v 729.745n 0.0v 729.755n 0.0v 734.745n 0.0v 734.755n 0.0v 739.745n 0.0v 739.755n 1.1v 744.745n 1.1v 744.755n 1.1v 749.745n 1.1v 749.755n 1.1v 754.745n 1.1v 754.755n 1.1v 759.745n 1.1v 759.755n 1.1v 764.745n 1.1v 764.755n 1.1v 769.745n 1.1v 769.755n 1.1v 774.745n 1.1v 774.755n 1.1v 779.745n 1.1v 779.755n 1.1v 784.745n 1.1v 784.755n 1.1v 789.745n 1.1v 789.755n 0.0v 794.745n 0.0v 794.755n 0.0v 799.745n 0.0v 799.755n 0.0v 804.745n 0.0v 804.755n 0.0v 809.745n 0.0v 809.755n 0.0v 814.745n 0.0v 814.755n 0.0v 819.745n 0.0v 819.755n 0.0v 824.745n 0.0v 824.755n 0.0v 829.745n 0.0v 829.755n 0.0v 834.745n 0.0v 834.755n 0.0v 839.745n 0.0v 839.755n 0.0v 844.745n 0.0v 844.755n 1.1v 849.745n 1.1v 849.755n 1.1v 854.745n 1.1v 854.755n 1.1v 859.745n 1.1v 859.755n 1.1v 864.745n 1.1v 864.755n 1.1v 869.745n 1.1v 869.755n 1.1v 874.745n 1.1v 874.755n 1.1v 879.745n 1.1v 879.755n 1.1v 884.745n 1.1v 884.755n 1.1v 889.745n 1.1v 889.755n 0.0v 894.745n 0.0v 894.755n 0.0v 899.745n 0.0v 899.755n 0.0v 904.745n 0.0v 904.755n 0.0v 909.745n 0.0v 909.755n 1.1v 914.745n 1.1v 914.755n 1.1v 919.745n 1.1v 919.755n 1.1v 924.745n 1.1v 924.755n 1.1v 929.745n 1.1v 929.755n 1.1v 934.745n 1.1v 934.755n 1.1v 939.745n 1.1v 939.755n 1.1v 944.745n 1.1v 944.755n 1.1v 949.745n 1.1v 949.755n 1.1v 954.745n 1.1v 954.755n 1.1v 959.745n 1.1v 959.755n 1.1v 964.745n 1.1v 964.755n 1.1v 969.745n 1.1v 969.755n 1.1v 974.745n 1.1v 974.755n 1.1v 979.745n 1.1v 979.755n 1.1v 984.745n 1.1v 984.755n 1.1v 989.745n 1.1v 989.755n 1.1v 994.745n 1.1v 994.755n 1.1v 999.745n 1.1v 999.755n 1.1v 1004.745n 1.1v 1004.755n 0.0v 1009.745n 0.0v 1009.755n 0.0v 1014.745n 0.0v 1014.755n 0.0v 1019.745n 0.0v 1019.755n 0.0v 1024.745n 0.0v 1024.755n 0.0v )
* (time, data): [(0, 0), (5, 0), (10, 0), (15, 1), (20, 1), (25, 1), (30, 0), (35, 1), (40, 1), (45, 1), (50, 1), (55, 1), (60, 0), (65, 1), (70, 1), (75, 1), (80, 0), (85, 0), (90, 0), (95, 0), (100, 0), (105, 0), (110, 1), (115, 0), (120, 0), (125, 0), (130, 1), (135, 0), (140, 1), (145, 1), (150, 1), (155, 0), (160, 0), (165, 0), (170, 0), (175, 0), (180, 0), (185, 0), (190, 0), (195, 0), (200, 0), (205, 0), (210, 0), (215, 0), (220, 0), (225, 0), (230, 0), (235, 0), (240, 0), (245, 0), (250, 0), (255, 0), (260, 0), (265, 0), (270, 1), (275, 1), (280, 1), (285, 1), (290, 1), (295, 1), (300, 1), (305, 1), (310, 1), (315, 1), (320, 1), (325, 1), (330, 1), (335, 1), (340, 1), (345, 1), (350, 1), (355, 0), (360, 0), (365, 0), (370, 0), (375, 0), (380, 1), (385, 1), (390, 1), (395, 1), (400, 1), (405, 1), (410, 1), (415, 1), (420, 0), (425, 0), (430, 0), (435, 0), (440, 0), (445, 0), (450, 0), (455, 0), (460, 0), (465, 0), (470, 1), (475, 0), (480, 0), (485, 0), (490, 0), (495, 1), (500, 1), (505, 1), (510, 1), (515, 1), (520, 0), (525, 0), (530, 0), (535, 1), (540, 1), (545, 1), (550, 1), (555, 1), (560, 1), (565, 1), (570, 1), (575, 1), (580, 1), (585, 1), (590, 1), (595, 1), (600, 1), (605, 1), (610, 1), (615, 1), (620, 1), (625, 1), (630, 1), (635, 1), (640, 1), (645, 0), (650, 0), (655, 0), (660, 1), (665, 1), (670, 1), (675, 1), (680, 0), (685, 0), (690, 0), (695, 0), (700, 0), (705, 0), (710, 1), (715, 0), (720, 0), (725, 0), (730, 0), (735, 0), (740, 0), (745, 0), (750, 0), (755, 0), (760, 0), (765, 0), (770, 1), (775, 1), (780, 1), (785, 1), (790, 0), (795, 1), (800, 1), (805, 1), (810, 1), (815, 1), (820, 1), (825, 1), (830, 1), (835, 1), (840, 1), (845, 0), (850, 0), (855, 0), (860, 0), (865, 0), (870, 0), (875, 0), (880, 0), (885, 0), (890, 1), (895, 1), (900, 0), (905, 0), (910, 0), (915, 0), (920, 0), (925, 0), (930, 0), (935, 0), (940, 0), (945, 0), (950, 0), (955, 0), (960, 0), (965, 0), (970, 0), (975, 1), (980, 1), (985, 1), (990, 1), (995, 0), (1000, 0), (1005, 1), (1010, 1), (1015, 1), (1020, 1), (1025, 1)]
Vdin0_29  din0_29  0 PWL (0n 0.0v 4.745n 0.0v 4.755n 0.0v 9.745n 0.0v 9.755n 0.0v 14.745n 0.0v 14.755n 1.1v 19.745n 1.1v 19.755n 1.1v 24.745n 1.1v 24.755n 1.1v 29.745n 1.1v 29.755n 0.0v 34.745n 0.0v 34.755n 1.1v 39.745n 1.1v 39.755n 1.1v 44.745n 1.1v 44.755n 1.1v 49.745n 1.1v 49.755n 1.1v 54.745n 1.1v 54.755n 1.1v 59.745n 1.1v 59.755n 0.0v 64.745n 0.0v 64.755n 1.1v 69.745n 1.1v 69.755n 1.1v 74.745n 1.1v 74.755n 1.1v 79.745n 1.1v 79.755n 0.0v 84.745n 0.0v 84.755n 0.0v 89.745n 0.0v 89.755n 0.0v 94.745n 0.0v 94.755n 0.0v 99.745n 0.0v 99.755n 0.0v 104.745n 0.0v 104.755n 0.0v 109.745n 0.0v 109.755n 1.1v 114.745n 1.1v 114.755n 0.0v 119.745n 0.0v 119.755n 0.0v 124.745n 0.0v 124.755n 0.0v 129.745n 0.0v 129.755n 1.1v 134.745n 1.1v 134.755n 0.0v 139.745n 0.0v 139.755n 1.1v 144.745n 1.1v 144.755n 1.1v 149.745n 1.1v 149.755n 1.1v 154.745n 1.1v 154.755n 0.0v 159.745n 0.0v 159.755n 0.0v 164.745n 0.0v 164.755n 0.0v 169.745n 0.0v 169.755n 0.0v 174.745n 0.0v 174.755n 0.0v 179.745n 0.0v 179.755n 0.0v 184.745n 0.0v 184.755n 0.0v 189.745n 0.0v 189.755n 0.0v 194.745n 0.0v 194.755n 0.0v 199.745n 0.0v 199.755n 0.0v 204.745n 0.0v 204.755n 0.0v 209.745n 0.0v 209.755n 0.0v 214.745n 0.0v 214.755n 0.0v 219.745n 0.0v 219.755n 0.0v 224.745n 0.0v 224.755n 0.0v 229.745n 0.0v 229.755n 0.0v 234.745n 0.0v 234.755n 0.0v 239.745n 0.0v 239.755n 0.0v 244.745n 0.0v 244.755n 0.0v 249.745n 0.0v 249.755n 0.0v 254.745n 0.0v 254.755n 0.0v 259.745n 0.0v 259.755n 0.0v 264.745n 0.0v 264.755n 0.0v 269.745n 0.0v 269.755n 1.1v 274.745n 1.1v 274.755n 1.1v 279.745n 1.1v 279.755n 1.1v 284.745n 1.1v 284.755n 1.1v 289.745n 1.1v 289.755n 1.1v 294.745n 1.1v 294.755n 1.1v 299.745n 1.1v 299.755n 1.1v 304.745n 1.1v 304.755n 1.1v 309.745n 1.1v 309.755n 1.1v 314.745n 1.1v 314.755n 1.1v 319.745n 1.1v 319.755n 1.1v 324.745n 1.1v 324.755n 1.1v 329.745n 1.1v 329.755n 1.1v 334.745n 1.1v 334.755n 1.1v 339.745n 1.1v 339.755n 1.1v 344.745n 1.1v 344.755n 1.1v 349.745n 1.1v 349.755n 1.1v 354.745n 1.1v 354.755n 0.0v 359.745n 0.0v 359.755n 0.0v 364.745n 0.0v 364.755n 0.0v 369.745n 0.0v 369.755n 0.0v 374.745n 0.0v 374.755n 0.0v 379.745n 0.0v 379.755n 1.1v 384.745n 1.1v 384.755n 1.1v 389.745n 1.1v 389.755n 1.1v 394.745n 1.1v 394.755n 1.1v 399.745n 1.1v 399.755n 1.1v 404.745n 1.1v 404.755n 1.1v 409.745n 1.1v 409.755n 1.1v 414.745n 1.1v 414.755n 1.1v 419.745n 1.1v 419.755n 0.0v 424.745n 0.0v 424.755n 0.0v 429.745n 0.0v 429.755n 0.0v 434.745n 0.0v 434.755n 0.0v 439.745n 0.0v 439.755n 0.0v 444.745n 0.0v 444.755n 0.0v 449.745n 0.0v 449.755n 0.0v 454.745n 0.0v 454.755n 0.0v 459.745n 0.0v 459.755n 0.0v 464.745n 0.0v 464.755n 0.0v 469.745n 0.0v 469.755n 1.1v 474.745n 1.1v 474.755n 0.0v 479.745n 0.0v 479.755n 0.0v 484.745n 0.0v 484.755n 0.0v 489.745n 0.0v 489.755n 0.0v 494.745n 0.0v 494.755n 1.1v 499.745n 1.1v 499.755n 1.1v 504.745n 1.1v 504.755n 1.1v 509.745n 1.1v 509.755n 1.1v 514.745n 1.1v 514.755n 1.1v 519.745n 1.1v 519.755n 0.0v 524.745n 0.0v 524.755n 0.0v 529.745n 0.0v 529.755n 0.0v 534.745n 0.0v 534.755n 1.1v 539.745n 1.1v 539.755n 1.1v 544.745n 1.1v 544.755n 1.1v 549.745n 1.1v 549.755n 1.1v 554.745n 1.1v 554.755n 1.1v 559.745n 1.1v 559.755n 1.1v 564.745n 1.1v 564.755n 1.1v 569.745n 1.1v 569.755n 1.1v 574.745n 1.1v 574.755n 1.1v 579.745n 1.1v 579.755n 1.1v 584.745n 1.1v 584.755n 1.1v 589.745n 1.1v 589.755n 1.1v 594.745n 1.1v 594.755n 1.1v 599.745n 1.1v 599.755n 1.1v 604.745n 1.1v 604.755n 1.1v 609.745n 1.1v 609.755n 1.1v 614.745n 1.1v 614.755n 1.1v 619.745n 1.1v 619.755n 1.1v 624.745n 1.1v 624.755n 1.1v 629.745n 1.1v 629.755n 1.1v 634.745n 1.1v 634.755n 1.1v 639.745n 1.1v 639.755n 1.1v 644.745n 1.1v 644.755n 0.0v 649.745n 0.0v 649.755n 0.0v 654.745n 0.0v 654.755n 0.0v 659.745n 0.0v 659.755n 1.1v 664.745n 1.1v 664.755n 1.1v 669.745n 1.1v 669.755n 1.1v 674.745n 1.1v 674.755n 1.1v 679.745n 1.1v 679.755n 0.0v 684.745n 0.0v 684.755n 0.0v 689.745n 0.0v 689.755n 0.0v 694.745n 0.0v 694.755n 0.0v 699.745n 0.0v 699.755n 0.0v 704.745n 0.0v 704.755n 0.0v 709.745n 0.0v 709.755n 1.1v 714.745n 1.1v 714.755n 0.0v 719.745n 0.0v 719.755n 0.0v 724.745n 0.0v 724.755n 0.0v 729.745n 0.0v 729.755n 0.0v 734.745n 0.0v 734.755n 0.0v 739.745n 0.0v 739.755n 0.0v 744.745n 0.0v 744.755n 0.0v 749.745n 0.0v 749.755n 0.0v 754.745n 0.0v 754.755n 0.0v 759.745n 0.0v 759.755n 0.0v 764.745n 0.0v 764.755n 0.0v 769.745n 0.0v 769.755n 1.1v 774.745n 1.1v 774.755n 1.1v 779.745n 1.1v 779.755n 1.1v 784.745n 1.1v 784.755n 1.1v 789.745n 1.1v 789.755n 0.0v 794.745n 0.0v 794.755n 1.1v 799.745n 1.1v 799.755n 1.1v 804.745n 1.1v 804.755n 1.1v 809.745n 1.1v 809.755n 1.1v 814.745n 1.1v 814.755n 1.1v 819.745n 1.1v 819.755n 1.1v 824.745n 1.1v 824.755n 1.1v 829.745n 1.1v 829.755n 1.1v 834.745n 1.1v 834.755n 1.1v 839.745n 1.1v 839.755n 1.1v 844.745n 1.1v 844.755n 0.0v 849.745n 0.0v 849.755n 0.0v 854.745n 0.0v 854.755n 0.0v 859.745n 0.0v 859.755n 0.0v 864.745n 0.0v 864.755n 0.0v 869.745n 0.0v 869.755n 0.0v 874.745n 0.0v 874.755n 0.0v 879.745n 0.0v 879.755n 0.0v 884.745n 0.0v 884.755n 0.0v 889.745n 0.0v 889.755n 1.1v 894.745n 1.1v 894.755n 1.1v 899.745n 1.1v 899.755n 0.0v 904.745n 0.0v 904.755n 0.0v 909.745n 0.0v 909.755n 0.0v 914.745n 0.0v 914.755n 0.0v 919.745n 0.0v 919.755n 0.0v 924.745n 0.0v 924.755n 0.0v 929.745n 0.0v 929.755n 0.0v 934.745n 0.0v 934.755n 0.0v 939.745n 0.0v 939.755n 0.0v 944.745n 0.0v 944.755n 0.0v 949.745n 0.0v 949.755n 0.0v 954.745n 0.0v 954.755n 0.0v 959.745n 0.0v 959.755n 0.0v 964.745n 0.0v 964.755n 0.0v 969.745n 0.0v 969.755n 0.0v 974.745n 0.0v 974.755n 1.1v 979.745n 1.1v 979.755n 1.1v 984.745n 1.1v 984.755n 1.1v 989.745n 1.1v 989.755n 1.1v 994.745n 1.1v 994.755n 0.0v 999.745n 0.0v 999.755n 0.0v 1004.745n 0.0v 1004.755n 1.1v 1009.745n 1.1v 1009.755n 1.1v 1014.745n 1.1v 1014.755n 1.1v 1019.745n 1.1v 1019.755n 1.1v 1024.745n 1.1v 1024.755n 1.1v )
* (time, data): [(0, 0), (5, 1), (10, 1), (15, 0), (20, 0), (25, 0), (30, 1), (35, 1), (40, 1), (45, 1), (50, 1), (55, 1), (60, 0), (65, 0), (70, 0), (75, 0), (80, 0), (85, 0), (90, 0), (95, 1), (100, 1), (105, 1), (110, 1), (115, 1), (120, 1), (125, 1), (130, 0), (135, 1), (140, 1), (145, 1), (150, 1), (155, 0), (160, 0), (165, 0), (170, 0), (175, 0), (180, 0), (185, 0), (190, 0), (195, 0), (200, 0), (205, 0), (210, 0), (215, 0), (220, 0), (225, 0), (230, 0), (235, 0), (240, 0), (245, 0), (250, 0), (255, 0), (260, 0), (265, 1), (270, 1), (275, 1), (280, 1), (285, 1), (290, 1), (295, 1), (300, 1), (305, 1), (310, 1), (315, 1), (320, 1), (325, 1), (330, 1), (335, 1), (340, 1), (345, 1), (350, 1), (355, 1), (360, 1), (365, 1), (370, 1), (375, 1), (380, 0), (385, 0), (390, 0), (395, 0), (400, 0), (405, 0), (410, 0), (415, 0), (420, 0), (425, 0), (430, 0), (435, 0), (440, 0), (445, 0), (450, 0), (455, 0), (460, 0), (465, 0), (470, 0), (475, 1), (480, 1), (485, 1), (490, 1), (495, 1), (500, 1), (505, 1), (510, 1), (515, 1), (520, 1), (525, 1), (530, 1), (535, 0), (540, 0), (545, 0), (550, 0), (555, 0), (560, 0), (565, 0), (570, 0), (575, 0), (580, 0), (585, 0), (590, 0), (595, 0), (600, 0), (605, 0), (610, 0), (615, 0), (620, 1), (625, 1), (630, 1), (635, 1), (640, 1), (645, 0), (650, 0), (655, 0), (660, 0), (665, 0), (670, 0), (675, 1), (680, 0), (685, 0), (690, 0), (695, 0), (700, 0), (705, 0), (710, 0), (715, 0), (720, 0), (725, 0), (730, 0), (735, 0), (740, 0), (745, 0), (750, 0), (755, 0), (760, 0), (765, 0), (770, 0), (775, 0), (780, 0), (785, 0), (790, 0), (795, 0), (800, 0), (805, 0), (810, 0), (815, 0), (820, 0), (825, 0), (830, 0), (835, 0), (840, 0), (845, 1), (850, 1), (855, 1), (860, 1), (865, 1), (870, 1), (875, 1), (880, 1), (885, 1), (890, 1), (895, 1), (900, 1), (905, 1), (910, 1), (915, 1), (920, 1), (925, 1), (930, 1), (935, 1), (940, 1), (945, 1), (950, 1), (955, 1), (960, 1), (965, 1), (970, 1), (975, 1), (980, 1), (985, 1), (990, 1), (995, 0), (1000, 0), (1005, 1), (1010, 1), (1015, 1), (1020, 1), (1025, 1)]
Vdin0_30  din0_30  0 PWL (0n 0.0v 4.745n 0.0v 4.755n 1.1v 9.745n 1.1v 9.755n 1.1v 14.745n 1.1v 14.755n 0.0v 19.745n 0.0v 19.755n 0.0v 24.745n 0.0v 24.755n 0.0v 29.745n 0.0v 29.755n 1.1v 34.745n 1.1v 34.755n 1.1v 39.745n 1.1v 39.755n 1.1v 44.745n 1.1v 44.755n 1.1v 49.745n 1.1v 49.755n 1.1v 54.745n 1.1v 54.755n 1.1v 59.745n 1.1v 59.755n 0.0v 64.745n 0.0v 64.755n 0.0v 69.745n 0.0v 69.755n 0.0v 74.745n 0.0v 74.755n 0.0v 79.745n 0.0v 79.755n 0.0v 84.745n 0.0v 84.755n 0.0v 89.745n 0.0v 89.755n 0.0v 94.745n 0.0v 94.755n 1.1v 99.745n 1.1v 99.755n 1.1v 104.745n 1.1v 104.755n 1.1v 109.745n 1.1v 109.755n 1.1v 114.745n 1.1v 114.755n 1.1v 119.745n 1.1v 119.755n 1.1v 124.745n 1.1v 124.755n 1.1v 129.745n 1.1v 129.755n 0.0v 134.745n 0.0v 134.755n 1.1v 139.745n 1.1v 139.755n 1.1v 144.745n 1.1v 144.755n 1.1v 149.745n 1.1v 149.755n 1.1v 154.745n 1.1v 154.755n 0.0v 159.745n 0.0v 159.755n 0.0v 164.745n 0.0v 164.755n 0.0v 169.745n 0.0v 169.755n 0.0v 174.745n 0.0v 174.755n 0.0v 179.745n 0.0v 179.755n 0.0v 184.745n 0.0v 184.755n 0.0v 189.745n 0.0v 189.755n 0.0v 194.745n 0.0v 194.755n 0.0v 199.745n 0.0v 199.755n 0.0v 204.745n 0.0v 204.755n 0.0v 209.745n 0.0v 209.755n 0.0v 214.745n 0.0v 214.755n 0.0v 219.745n 0.0v 219.755n 0.0v 224.745n 0.0v 224.755n 0.0v 229.745n 0.0v 229.755n 0.0v 234.745n 0.0v 234.755n 0.0v 239.745n 0.0v 239.755n 0.0v 244.745n 0.0v 244.755n 0.0v 249.745n 0.0v 249.755n 0.0v 254.745n 0.0v 254.755n 0.0v 259.745n 0.0v 259.755n 0.0v 264.745n 0.0v 264.755n 1.1v 269.745n 1.1v 269.755n 1.1v 274.745n 1.1v 274.755n 1.1v 279.745n 1.1v 279.755n 1.1v 284.745n 1.1v 284.755n 1.1v 289.745n 1.1v 289.755n 1.1v 294.745n 1.1v 294.755n 1.1v 299.745n 1.1v 299.755n 1.1v 304.745n 1.1v 304.755n 1.1v 309.745n 1.1v 309.755n 1.1v 314.745n 1.1v 314.755n 1.1v 319.745n 1.1v 319.755n 1.1v 324.745n 1.1v 324.755n 1.1v 329.745n 1.1v 329.755n 1.1v 334.745n 1.1v 334.755n 1.1v 339.745n 1.1v 339.755n 1.1v 344.745n 1.1v 344.755n 1.1v 349.745n 1.1v 349.755n 1.1v 354.745n 1.1v 354.755n 1.1v 359.745n 1.1v 359.755n 1.1v 364.745n 1.1v 364.755n 1.1v 369.745n 1.1v 369.755n 1.1v 374.745n 1.1v 374.755n 1.1v 379.745n 1.1v 379.755n 0.0v 384.745n 0.0v 384.755n 0.0v 389.745n 0.0v 389.755n 0.0v 394.745n 0.0v 394.755n 0.0v 399.745n 0.0v 399.755n 0.0v 404.745n 0.0v 404.755n 0.0v 409.745n 0.0v 409.755n 0.0v 414.745n 0.0v 414.755n 0.0v 419.745n 0.0v 419.755n 0.0v 424.745n 0.0v 424.755n 0.0v 429.745n 0.0v 429.755n 0.0v 434.745n 0.0v 434.755n 0.0v 439.745n 0.0v 439.755n 0.0v 444.745n 0.0v 444.755n 0.0v 449.745n 0.0v 449.755n 0.0v 454.745n 0.0v 454.755n 0.0v 459.745n 0.0v 459.755n 0.0v 464.745n 0.0v 464.755n 0.0v 469.745n 0.0v 469.755n 0.0v 474.745n 0.0v 474.755n 1.1v 479.745n 1.1v 479.755n 1.1v 484.745n 1.1v 484.755n 1.1v 489.745n 1.1v 489.755n 1.1v 494.745n 1.1v 494.755n 1.1v 499.745n 1.1v 499.755n 1.1v 504.745n 1.1v 504.755n 1.1v 509.745n 1.1v 509.755n 1.1v 514.745n 1.1v 514.755n 1.1v 519.745n 1.1v 519.755n 1.1v 524.745n 1.1v 524.755n 1.1v 529.745n 1.1v 529.755n 1.1v 534.745n 1.1v 534.755n 0.0v 539.745n 0.0v 539.755n 0.0v 544.745n 0.0v 544.755n 0.0v 549.745n 0.0v 549.755n 0.0v 554.745n 0.0v 554.755n 0.0v 559.745n 0.0v 559.755n 0.0v 564.745n 0.0v 564.755n 0.0v 569.745n 0.0v 569.755n 0.0v 574.745n 0.0v 574.755n 0.0v 579.745n 0.0v 579.755n 0.0v 584.745n 0.0v 584.755n 0.0v 589.745n 0.0v 589.755n 0.0v 594.745n 0.0v 594.755n 0.0v 599.745n 0.0v 599.755n 0.0v 604.745n 0.0v 604.755n 0.0v 609.745n 0.0v 609.755n 0.0v 614.745n 0.0v 614.755n 0.0v 619.745n 0.0v 619.755n 1.1v 624.745n 1.1v 624.755n 1.1v 629.745n 1.1v 629.755n 1.1v 634.745n 1.1v 634.755n 1.1v 639.745n 1.1v 639.755n 1.1v 644.745n 1.1v 644.755n 0.0v 649.745n 0.0v 649.755n 0.0v 654.745n 0.0v 654.755n 0.0v 659.745n 0.0v 659.755n 0.0v 664.745n 0.0v 664.755n 0.0v 669.745n 0.0v 669.755n 0.0v 674.745n 0.0v 674.755n 1.1v 679.745n 1.1v 679.755n 0.0v 684.745n 0.0v 684.755n 0.0v 689.745n 0.0v 689.755n 0.0v 694.745n 0.0v 694.755n 0.0v 699.745n 0.0v 699.755n 0.0v 704.745n 0.0v 704.755n 0.0v 709.745n 0.0v 709.755n 0.0v 714.745n 0.0v 714.755n 0.0v 719.745n 0.0v 719.755n 0.0v 724.745n 0.0v 724.755n 0.0v 729.745n 0.0v 729.755n 0.0v 734.745n 0.0v 734.755n 0.0v 739.745n 0.0v 739.755n 0.0v 744.745n 0.0v 744.755n 0.0v 749.745n 0.0v 749.755n 0.0v 754.745n 0.0v 754.755n 0.0v 759.745n 0.0v 759.755n 0.0v 764.745n 0.0v 764.755n 0.0v 769.745n 0.0v 769.755n 0.0v 774.745n 0.0v 774.755n 0.0v 779.745n 0.0v 779.755n 0.0v 784.745n 0.0v 784.755n 0.0v 789.745n 0.0v 789.755n 0.0v 794.745n 0.0v 794.755n 0.0v 799.745n 0.0v 799.755n 0.0v 804.745n 0.0v 804.755n 0.0v 809.745n 0.0v 809.755n 0.0v 814.745n 0.0v 814.755n 0.0v 819.745n 0.0v 819.755n 0.0v 824.745n 0.0v 824.755n 0.0v 829.745n 0.0v 829.755n 0.0v 834.745n 0.0v 834.755n 0.0v 839.745n 0.0v 839.755n 0.0v 844.745n 0.0v 844.755n 1.1v 849.745n 1.1v 849.755n 1.1v 854.745n 1.1v 854.755n 1.1v 859.745n 1.1v 859.755n 1.1v 864.745n 1.1v 864.755n 1.1v 869.745n 1.1v 869.755n 1.1v 874.745n 1.1v 874.755n 1.1v 879.745n 1.1v 879.755n 1.1v 884.745n 1.1v 884.755n 1.1v 889.745n 1.1v 889.755n 1.1v 894.745n 1.1v 894.755n 1.1v 899.745n 1.1v 899.755n 1.1v 904.745n 1.1v 904.755n 1.1v 909.745n 1.1v 909.755n 1.1v 914.745n 1.1v 914.755n 1.1v 919.745n 1.1v 919.755n 1.1v 924.745n 1.1v 924.755n 1.1v 929.745n 1.1v 929.755n 1.1v 934.745n 1.1v 934.755n 1.1v 939.745n 1.1v 939.755n 1.1v 944.745n 1.1v 944.755n 1.1v 949.745n 1.1v 949.755n 1.1v 954.745n 1.1v 954.755n 1.1v 959.745n 1.1v 959.755n 1.1v 964.745n 1.1v 964.755n 1.1v 969.745n 1.1v 969.755n 1.1v 974.745n 1.1v 974.755n 1.1v 979.745n 1.1v 979.755n 1.1v 984.745n 1.1v 984.755n 1.1v 989.745n 1.1v 989.755n 1.1v 994.745n 1.1v 994.755n 0.0v 999.745n 0.0v 999.755n 0.0v 1004.745n 0.0v 1004.755n 1.1v 1009.745n 1.1v 1009.755n 1.1v 1014.745n 1.1v 1014.755n 1.1v 1019.745n 1.1v 1019.755n 1.1v 1024.745n 1.1v 1024.755n 1.1v )
* (time, data): [(0, 0), (5, 1), (10, 0), (15, 1), (20, 1), (25, 1), (30, 1), (35, 1), (40, 1), (45, 1), (50, 1), (55, 1), (60, 1), (65, 0), (70, 0), (75, 0), (80, 0), (85, 0), (90, 0), (95, 0), (100, 0), (105, 0), (110, 0), (115, 0), (120, 0), (125, 0), (130, 0), (135, 1), (140, 0), (145, 0), (150, 0), (155, 1), (160, 1), (165, 1), (170, 1), (175, 1), (180, 1), (185, 1), (190, 1), (195, 1), (200, 1), (205, 1), (210, 1), (215, 1), (220, 1), (225, 1), (230, 1), (235, 1), (240, 1), (245, 1), (250, 1), (255, 1), (260, 1), (265, 0), (270, 1), (275, 1), (280, 1), (285, 1), (290, 1), (295, 1), (300, 1), (305, 1), (310, 1), (315, 1), (320, 1), (325, 1), (330, 1), (335, 1), (340, 1), (345, 1), (350, 1), (355, 0), (360, 0), (365, 0), (370, 0), (375, 0), (380, 0), (385, 0), (390, 0), (395, 0), (400, 0), (405, 0), (410, 0), (415, 0), (420, 0), (425, 0), (430, 0), (435, 0), (440, 0), (445, 0), (450, 0), (455, 0), (460, 0), (465, 0), (470, 1), (475, 1), (480, 1), (485, 1), (490, 1), (495, 0), (500, 0), (505, 0), (510, 0), (515, 0), (520, 1), (525, 1), (530, 1), (535, 1), (540, 1), (545, 1), (550, 1), (555, 1), (560, 1), (565, 1), (570, 1), (575, 1), (580, 1), (585, 1), (590, 1), (595, 1), (600, 1), (605, 1), (610, 1), (615, 1), (620, 1), (625, 1), (630, 1), (635, 1), (640, 1), (645, 1), (650, 1), (655, 1), (660, 0), (665, 1), (670, 1), (675, 1), (680, 0), (685, 0), (690, 0), (695, 0), (700, 0), (705, 0), (710, 0), (715, 0), (720, 0), (725, 0), (730, 0), (735, 0), (740, 0), (745, 0), (750, 0), (755, 0), (760, 1), (765, 1), (770, 1), (775, 1), (780, 1), (785, 0), (790, 0), (795, 0), (800, 0), (805, 0), (810, 0), (815, 0), (820, 0), (825, 0), (830, 0), (835, 0), (840, 0), (845, 1), (850, 1), (855, 1), (860, 1), (865, 0), (870, 0), (875, 0), (880, 0), (885, 0), (890, 1), (895, 1), (900, 0), (905, 0), (910, 0), (915, 0), (920, 0), (925, 0), (930, 0), (935, 0), (940, 0), (945, 0), (950, 0), (955, 0), (960, 0), (965, 0), (970, 0), (975, 0), (980, 0), (985, 0), (990, 0), (995, 1), (1000, 1), (1005, 0), (1010, 0), (1015, 0), (1020, 0), (1025, 0)]
Vdin0_31  din0_31  0 PWL (0n 0.0v 4.745n 0.0v 4.755n 1.1v 9.745n 1.1v 9.755n 0.0v 14.745n 0.0v 14.755n 1.1v 19.745n 1.1v 19.755n 1.1v 24.745n 1.1v 24.755n 1.1v 29.745n 1.1v 29.755n 1.1v 34.745n 1.1v 34.755n 1.1v 39.745n 1.1v 39.755n 1.1v 44.745n 1.1v 44.755n 1.1v 49.745n 1.1v 49.755n 1.1v 54.745n 1.1v 54.755n 1.1v 59.745n 1.1v 59.755n 1.1v 64.745n 1.1v 64.755n 0.0v 69.745n 0.0v 69.755n 0.0v 74.745n 0.0v 74.755n 0.0v 79.745n 0.0v 79.755n 0.0v 84.745n 0.0v 84.755n 0.0v 89.745n 0.0v 89.755n 0.0v 94.745n 0.0v 94.755n 0.0v 99.745n 0.0v 99.755n 0.0v 104.745n 0.0v 104.755n 0.0v 109.745n 0.0v 109.755n 0.0v 114.745n 0.0v 114.755n 0.0v 119.745n 0.0v 119.755n 0.0v 124.745n 0.0v 124.755n 0.0v 129.745n 0.0v 129.755n 0.0v 134.745n 0.0v 134.755n 1.1v 139.745n 1.1v 139.755n 0.0v 144.745n 0.0v 144.755n 0.0v 149.745n 0.0v 149.755n 0.0v 154.745n 0.0v 154.755n 1.1v 159.745n 1.1v 159.755n 1.1v 164.745n 1.1v 164.755n 1.1v 169.745n 1.1v 169.755n 1.1v 174.745n 1.1v 174.755n 1.1v 179.745n 1.1v 179.755n 1.1v 184.745n 1.1v 184.755n 1.1v 189.745n 1.1v 189.755n 1.1v 194.745n 1.1v 194.755n 1.1v 199.745n 1.1v 199.755n 1.1v 204.745n 1.1v 204.755n 1.1v 209.745n 1.1v 209.755n 1.1v 214.745n 1.1v 214.755n 1.1v 219.745n 1.1v 219.755n 1.1v 224.745n 1.1v 224.755n 1.1v 229.745n 1.1v 229.755n 1.1v 234.745n 1.1v 234.755n 1.1v 239.745n 1.1v 239.755n 1.1v 244.745n 1.1v 244.755n 1.1v 249.745n 1.1v 249.755n 1.1v 254.745n 1.1v 254.755n 1.1v 259.745n 1.1v 259.755n 1.1v 264.745n 1.1v 264.755n 0.0v 269.745n 0.0v 269.755n 1.1v 274.745n 1.1v 274.755n 1.1v 279.745n 1.1v 279.755n 1.1v 284.745n 1.1v 284.755n 1.1v 289.745n 1.1v 289.755n 1.1v 294.745n 1.1v 294.755n 1.1v 299.745n 1.1v 299.755n 1.1v 304.745n 1.1v 304.755n 1.1v 309.745n 1.1v 309.755n 1.1v 314.745n 1.1v 314.755n 1.1v 319.745n 1.1v 319.755n 1.1v 324.745n 1.1v 324.755n 1.1v 329.745n 1.1v 329.755n 1.1v 334.745n 1.1v 334.755n 1.1v 339.745n 1.1v 339.755n 1.1v 344.745n 1.1v 344.755n 1.1v 349.745n 1.1v 349.755n 1.1v 354.745n 1.1v 354.755n 0.0v 359.745n 0.0v 359.755n 0.0v 364.745n 0.0v 364.755n 0.0v 369.745n 0.0v 369.755n 0.0v 374.745n 0.0v 374.755n 0.0v 379.745n 0.0v 379.755n 0.0v 384.745n 0.0v 384.755n 0.0v 389.745n 0.0v 389.755n 0.0v 394.745n 0.0v 394.755n 0.0v 399.745n 0.0v 399.755n 0.0v 404.745n 0.0v 404.755n 0.0v 409.745n 0.0v 409.755n 0.0v 414.745n 0.0v 414.755n 0.0v 419.745n 0.0v 419.755n 0.0v 424.745n 0.0v 424.755n 0.0v 429.745n 0.0v 429.755n 0.0v 434.745n 0.0v 434.755n 0.0v 439.745n 0.0v 439.755n 0.0v 444.745n 0.0v 444.755n 0.0v 449.745n 0.0v 449.755n 0.0v 454.745n 0.0v 454.755n 0.0v 459.745n 0.0v 459.755n 0.0v 464.745n 0.0v 464.755n 0.0v 469.745n 0.0v 469.755n 1.1v 474.745n 1.1v 474.755n 1.1v 479.745n 1.1v 479.755n 1.1v 484.745n 1.1v 484.755n 1.1v 489.745n 1.1v 489.755n 1.1v 494.745n 1.1v 494.755n 0.0v 499.745n 0.0v 499.755n 0.0v 504.745n 0.0v 504.755n 0.0v 509.745n 0.0v 509.755n 0.0v 514.745n 0.0v 514.755n 0.0v 519.745n 0.0v 519.755n 1.1v 524.745n 1.1v 524.755n 1.1v 529.745n 1.1v 529.755n 1.1v 534.745n 1.1v 534.755n 1.1v 539.745n 1.1v 539.755n 1.1v 544.745n 1.1v 544.755n 1.1v 549.745n 1.1v 549.755n 1.1v 554.745n 1.1v 554.755n 1.1v 559.745n 1.1v 559.755n 1.1v 564.745n 1.1v 564.755n 1.1v 569.745n 1.1v 569.755n 1.1v 574.745n 1.1v 574.755n 1.1v 579.745n 1.1v 579.755n 1.1v 584.745n 1.1v 584.755n 1.1v 589.745n 1.1v 589.755n 1.1v 594.745n 1.1v 594.755n 1.1v 599.745n 1.1v 599.755n 1.1v 604.745n 1.1v 604.755n 1.1v 609.745n 1.1v 609.755n 1.1v 614.745n 1.1v 614.755n 1.1v 619.745n 1.1v 619.755n 1.1v 624.745n 1.1v 624.755n 1.1v 629.745n 1.1v 629.755n 1.1v 634.745n 1.1v 634.755n 1.1v 639.745n 1.1v 639.755n 1.1v 644.745n 1.1v 644.755n 1.1v 649.745n 1.1v 649.755n 1.1v 654.745n 1.1v 654.755n 1.1v 659.745n 1.1v 659.755n 0.0v 664.745n 0.0v 664.755n 1.1v 669.745n 1.1v 669.755n 1.1v 674.745n 1.1v 674.755n 1.1v 679.745n 1.1v 679.755n 0.0v 684.745n 0.0v 684.755n 0.0v 689.745n 0.0v 689.755n 0.0v 694.745n 0.0v 694.755n 0.0v 699.745n 0.0v 699.755n 0.0v 704.745n 0.0v 704.755n 0.0v 709.745n 0.0v 709.755n 0.0v 714.745n 0.0v 714.755n 0.0v 719.745n 0.0v 719.755n 0.0v 724.745n 0.0v 724.755n 0.0v 729.745n 0.0v 729.755n 0.0v 734.745n 0.0v 734.755n 0.0v 739.745n 0.0v 739.755n 0.0v 744.745n 0.0v 744.755n 0.0v 749.745n 0.0v 749.755n 0.0v 754.745n 0.0v 754.755n 0.0v 759.745n 0.0v 759.755n 1.1v 764.745n 1.1v 764.755n 1.1v 769.745n 1.1v 769.755n 1.1v 774.745n 1.1v 774.755n 1.1v 779.745n 1.1v 779.755n 1.1v 784.745n 1.1v 784.755n 0.0v 789.745n 0.0v 789.755n 0.0v 794.745n 0.0v 794.755n 0.0v 799.745n 0.0v 799.755n 0.0v 804.745n 0.0v 804.755n 0.0v 809.745n 0.0v 809.755n 0.0v 814.745n 0.0v 814.755n 0.0v 819.745n 0.0v 819.755n 0.0v 824.745n 0.0v 824.755n 0.0v 829.745n 0.0v 829.755n 0.0v 834.745n 0.0v 834.755n 0.0v 839.745n 0.0v 839.755n 0.0v 844.745n 0.0v 844.755n 1.1v 849.745n 1.1v 849.755n 1.1v 854.745n 1.1v 854.755n 1.1v 859.745n 1.1v 859.755n 1.1v 864.745n 1.1v 864.755n 0.0v 869.745n 0.0v 869.755n 0.0v 874.745n 0.0v 874.755n 0.0v 879.745n 0.0v 879.755n 0.0v 884.745n 0.0v 884.755n 0.0v 889.745n 0.0v 889.755n 1.1v 894.745n 1.1v 894.755n 1.1v 899.745n 1.1v 899.755n 0.0v 904.745n 0.0v 904.755n 0.0v 909.745n 0.0v 909.755n 0.0v 914.745n 0.0v 914.755n 0.0v 919.745n 0.0v 919.755n 0.0v 924.745n 0.0v 924.755n 0.0v 929.745n 0.0v 929.755n 0.0v 934.745n 0.0v 934.755n 0.0v 939.745n 0.0v 939.755n 0.0v 944.745n 0.0v 944.755n 0.0v 949.745n 0.0v 949.755n 0.0v 954.745n 0.0v 954.755n 0.0v 959.745n 0.0v 959.755n 0.0v 964.745n 0.0v 964.755n 0.0v 969.745n 0.0v 969.755n 0.0v 974.745n 0.0v 974.755n 0.0v 979.745n 0.0v 979.755n 0.0v 984.745n 0.0v 984.755n 0.0v 989.745n 0.0v 989.755n 0.0v 994.745n 0.0v 994.755n 1.1v 999.745n 1.1v 999.755n 1.1v 1004.745n 1.1v 1004.755n 0.0v 1009.745n 0.0v 1009.755n 0.0v 1014.745n 0.0v 1014.755n 0.0v 1019.745n 0.0v 1019.755n 0.0v 1024.745n 0.0v 1024.755n 0.0v )
* (time, data): [(0, 0), (5, 1), (10, 0), (15, 1), (20, 1), (25, 0), (30, 1), (35, 0), (40, 0), (45, 0), (50, 1), (55, 1), (60, 0), (65, 0), (70, 0), (75, 0), (80, 0), (85, 0), (90, 1), (95, 0), (100, 0), (105, 0), (110, 0), (115, 1), (120, 0), (125, 0), (130, 1), (135, 0), (140, 0), (145, 1), (150, 0), (155, 1), (160, 1), (165, 0), (170, 0), (175, 0), (180, 0), (185, 0), (190, 0), (195, 0), (200, 1), (205, 1), (210, 1), (215, 0), (220, 0), (225, 1), (230, 0), (235, 0), (240, 0), (245, 0), (250, 0), (255, 1), (260, 1), (265, 1), (270, 0), (275, 0), (280, 1), (285, 1), (290, 0), (295, 0), (300, 1), (305, 0), (310, 0), (315, 1), (320, 1), (325, 1), (330, 0), (335, 0), (340, 1), (345, 0), (350, 0), (355, 1), (360, 1), (365, 1), (370, 1), (375, 0), (380, 1), (385, 0), (390, 1), (395, 1), (400, 1), (405, 1), (410, 0), (415, 0), (420, 0), (425, 0), (430, 1), (435, 0), (440, 0), (445, 0), (450, 0), (455, 1), (460, 1), (465, 0), (470, 1), (475, 1), (480, 1), (485, 1), (490, 0), (495, 0), (500, 0), (505, 0), (510, 1), (515, 1), (520, 0), (525, 0), (530, 1), (535, 1), (540, 1), (545, 1), (550, 1), (555, 0), (560, 1), (565, 0), (570, 0), (575, 0), (580, 0), (585, 0), (590, 1), (595, 1), (600, 1), (605, 1), (610, 1), (615, 1), (620, 1), (625, 0), (630, 0), (635, 0), (640, 1), (645, 0), (650, 1), (655, 0), (660, 1), (665, 1), (670, 0), (675, 0), (680, 0), (685, 1), (690, 1), (695, 0), (700, 0), (705, 0), (710, 1), (715, 0), (720, 1), (725, 1), (730, 0), (735, 0), (740, 1), (745, 1), (750, 1), (755, 1), (760, 1), (765, 1), (770, 0), (775, 1), (780, 1), (785, 0), (790, 1), (795, 0), (800, 0), (805, 1), (810, 0), (815, 0), (820, 1), (825, 1), (830, 0), (835, 1), (840, 1), (845, 1), (850, 0), (855, 1), (860, 1), (865, 1), (870, 1), (875, 1), (880, 1), (885, 0), (890, 0), (895, 0), (900, 1), (905, 1), (910, 0), (915, 0), (920, 1), (925, 1), (930, 1), (935, 1), (940, 1), (945, 1), (950, 1), (955, 1), (960, 0), (965, 1), (970, 1), (975, 0), (980, 0), (985, 0), (990, 0), (995, 0), (1000, 0), (1005, 0), (1010, 0), (1015, 0), (1020, 1), (1025, 1)]
Va0_0  a0_0  0 PWL (0n 0.0v 4.745n 0.0v 4.755n 1.1v 9.745n 1.1v 9.755n 0.0v 14.745n 0.0v 14.755n 1.1v 19.745n 1.1v 19.755n 1.1v 24.745n 1.1v 24.755n 0.0v 29.745n 0.0v 29.755n 1.1v 34.745n 1.1v 34.755n 0.0v 39.745n 0.0v 39.755n 0.0v 44.745n 0.0v 44.755n 0.0v 49.745n 0.0v 49.755n 1.1v 54.745n 1.1v 54.755n 1.1v 59.745n 1.1v 59.755n 0.0v 64.745n 0.0v 64.755n 0.0v 69.745n 0.0v 69.755n 0.0v 74.745n 0.0v 74.755n 0.0v 79.745n 0.0v 79.755n 0.0v 84.745n 0.0v 84.755n 0.0v 89.745n 0.0v 89.755n 1.1v 94.745n 1.1v 94.755n 0.0v 99.745n 0.0v 99.755n 0.0v 104.745n 0.0v 104.755n 0.0v 109.745n 0.0v 109.755n 0.0v 114.745n 0.0v 114.755n 1.1v 119.745n 1.1v 119.755n 0.0v 124.745n 0.0v 124.755n 0.0v 129.745n 0.0v 129.755n 1.1v 134.745n 1.1v 134.755n 0.0v 139.745n 0.0v 139.755n 0.0v 144.745n 0.0v 144.755n 1.1v 149.745n 1.1v 149.755n 0.0v 154.745n 0.0v 154.755n 1.1v 159.745n 1.1v 159.755n 1.1v 164.745n 1.1v 164.755n 0.0v 169.745n 0.0v 169.755n 0.0v 174.745n 0.0v 174.755n 0.0v 179.745n 0.0v 179.755n 0.0v 184.745n 0.0v 184.755n 0.0v 189.745n 0.0v 189.755n 0.0v 194.745n 0.0v 194.755n 0.0v 199.745n 0.0v 199.755n 1.1v 204.745n 1.1v 204.755n 1.1v 209.745n 1.1v 209.755n 1.1v 214.745n 1.1v 214.755n 0.0v 219.745n 0.0v 219.755n 0.0v 224.745n 0.0v 224.755n 1.1v 229.745n 1.1v 229.755n 0.0v 234.745n 0.0v 234.755n 0.0v 239.745n 0.0v 239.755n 0.0v 244.745n 0.0v 244.755n 0.0v 249.745n 0.0v 249.755n 0.0v 254.745n 0.0v 254.755n 1.1v 259.745n 1.1v 259.755n 1.1v 264.745n 1.1v 264.755n 1.1v 269.745n 1.1v 269.755n 0.0v 274.745n 0.0v 274.755n 0.0v 279.745n 0.0v 279.755n 1.1v 284.745n 1.1v 284.755n 1.1v 289.745n 1.1v 289.755n 0.0v 294.745n 0.0v 294.755n 0.0v 299.745n 0.0v 299.755n 1.1v 304.745n 1.1v 304.755n 0.0v 309.745n 0.0v 309.755n 0.0v 314.745n 0.0v 314.755n 1.1v 319.745n 1.1v 319.755n 1.1v 324.745n 1.1v 324.755n 1.1v 329.745n 1.1v 329.755n 0.0v 334.745n 0.0v 334.755n 0.0v 339.745n 0.0v 339.755n 1.1v 344.745n 1.1v 344.755n 0.0v 349.745n 0.0v 349.755n 0.0v 354.745n 0.0v 354.755n 1.1v 359.745n 1.1v 359.755n 1.1v 364.745n 1.1v 364.755n 1.1v 369.745n 1.1v 369.755n 1.1v 374.745n 1.1v 374.755n 0.0v 379.745n 0.0v 379.755n 1.1v 384.745n 1.1v 384.755n 0.0v 389.745n 0.0v 389.755n 1.1v 394.745n 1.1v 394.755n 1.1v 399.745n 1.1v 399.755n 1.1v 404.745n 1.1v 404.755n 1.1v 409.745n 1.1v 409.755n 0.0v 414.745n 0.0v 414.755n 0.0v 419.745n 0.0v 419.755n 0.0v 424.745n 0.0v 424.755n 0.0v 429.745n 0.0v 429.755n 1.1v 434.745n 1.1v 434.755n 0.0v 439.745n 0.0v 439.755n 0.0v 444.745n 0.0v 444.755n 0.0v 449.745n 0.0v 449.755n 0.0v 454.745n 0.0v 454.755n 1.1v 459.745n 1.1v 459.755n 1.1v 464.745n 1.1v 464.755n 0.0v 469.745n 0.0v 469.755n 1.1v 474.745n 1.1v 474.755n 1.1v 479.745n 1.1v 479.755n 1.1v 484.745n 1.1v 484.755n 1.1v 489.745n 1.1v 489.755n 0.0v 494.745n 0.0v 494.755n 0.0v 499.745n 0.0v 499.755n 0.0v 504.745n 0.0v 504.755n 0.0v 509.745n 0.0v 509.755n 1.1v 514.745n 1.1v 514.755n 1.1v 519.745n 1.1v 519.755n 0.0v 524.745n 0.0v 524.755n 0.0v 529.745n 0.0v 529.755n 1.1v 534.745n 1.1v 534.755n 1.1v 539.745n 1.1v 539.755n 1.1v 544.745n 1.1v 544.755n 1.1v 549.745n 1.1v 549.755n 1.1v 554.745n 1.1v 554.755n 0.0v 559.745n 0.0v 559.755n 1.1v 564.745n 1.1v 564.755n 0.0v 569.745n 0.0v 569.755n 0.0v 574.745n 0.0v 574.755n 0.0v 579.745n 0.0v 579.755n 0.0v 584.745n 0.0v 584.755n 0.0v 589.745n 0.0v 589.755n 1.1v 594.745n 1.1v 594.755n 1.1v 599.745n 1.1v 599.755n 1.1v 604.745n 1.1v 604.755n 1.1v 609.745n 1.1v 609.755n 1.1v 614.745n 1.1v 614.755n 1.1v 619.745n 1.1v 619.755n 1.1v 624.745n 1.1v 624.755n 0.0v 629.745n 0.0v 629.755n 0.0v 634.745n 0.0v 634.755n 0.0v 639.745n 0.0v 639.755n 1.1v 644.745n 1.1v 644.755n 0.0v 649.745n 0.0v 649.755n 1.1v 654.745n 1.1v 654.755n 0.0v 659.745n 0.0v 659.755n 1.1v 664.745n 1.1v 664.755n 1.1v 669.745n 1.1v 669.755n 0.0v 674.745n 0.0v 674.755n 0.0v 679.745n 0.0v 679.755n 0.0v 684.745n 0.0v 684.755n 1.1v 689.745n 1.1v 689.755n 1.1v 694.745n 1.1v 694.755n 0.0v 699.745n 0.0v 699.755n 0.0v 704.745n 0.0v 704.755n 0.0v 709.745n 0.0v 709.755n 1.1v 714.745n 1.1v 714.755n 0.0v 719.745n 0.0v 719.755n 1.1v 724.745n 1.1v 724.755n 1.1v 729.745n 1.1v 729.755n 0.0v 734.745n 0.0v 734.755n 0.0v 739.745n 0.0v 739.755n 1.1v 744.745n 1.1v 744.755n 1.1v 749.745n 1.1v 749.755n 1.1v 754.745n 1.1v 754.755n 1.1v 759.745n 1.1v 759.755n 1.1v 764.745n 1.1v 764.755n 1.1v 769.745n 1.1v 769.755n 0.0v 774.745n 0.0v 774.755n 1.1v 779.745n 1.1v 779.755n 1.1v 784.745n 1.1v 784.755n 0.0v 789.745n 0.0v 789.755n 1.1v 794.745n 1.1v 794.755n 0.0v 799.745n 0.0v 799.755n 0.0v 804.745n 0.0v 804.755n 1.1v 809.745n 1.1v 809.755n 0.0v 814.745n 0.0v 814.755n 0.0v 819.745n 0.0v 819.755n 1.1v 824.745n 1.1v 824.755n 1.1v 829.745n 1.1v 829.755n 0.0v 834.745n 0.0v 834.755n 1.1v 839.745n 1.1v 839.755n 1.1v 844.745n 1.1v 844.755n 1.1v 849.745n 1.1v 849.755n 0.0v 854.745n 0.0v 854.755n 1.1v 859.745n 1.1v 859.755n 1.1v 864.745n 1.1v 864.755n 1.1v 869.745n 1.1v 869.755n 1.1v 874.745n 1.1v 874.755n 1.1v 879.745n 1.1v 879.755n 1.1v 884.745n 1.1v 884.755n 0.0v 889.745n 0.0v 889.755n 0.0v 894.745n 0.0v 894.755n 0.0v 899.745n 0.0v 899.755n 1.1v 904.745n 1.1v 904.755n 1.1v 909.745n 1.1v 909.755n 0.0v 914.745n 0.0v 914.755n 0.0v 919.745n 0.0v 919.755n 1.1v 924.745n 1.1v 924.755n 1.1v 929.745n 1.1v 929.755n 1.1v 934.745n 1.1v 934.755n 1.1v 939.745n 1.1v 939.755n 1.1v 944.745n 1.1v 944.755n 1.1v 949.745n 1.1v 949.755n 1.1v 954.745n 1.1v 954.755n 1.1v 959.745n 1.1v 959.755n 0.0v 964.745n 0.0v 964.755n 1.1v 969.745n 1.1v 969.755n 1.1v 974.745n 1.1v 974.755n 0.0v 979.745n 0.0v 979.755n 0.0v 984.745n 0.0v 984.755n 0.0v 989.745n 0.0v 989.755n 0.0v 994.745n 0.0v 994.755n 0.0v 999.745n 0.0v 999.755n 0.0v 1004.745n 0.0v 1004.755n 0.0v 1009.745n 0.0v 1009.755n 0.0v 1014.745n 0.0v 1014.755n 0.0v 1019.745n 0.0v 1019.755n 1.1v 1024.745n 1.1v 1024.755n 1.1v )
* (time, data): [(0, 0), (5, 0), (10, 1), (15, 0), (20, 0), (25, 1), (30, 1), (35, 1), (40, 1), (45, 1), (50, 0), (55, 1), (60, 0), (65, 1), (70, 1), (75, 1), (80, 0), (85, 0), (90, 0), (95, 0), (100, 0), (105, 0), (110, 0), (115, 0), (120, 0), (125, 0), (130, 1), (135, 0), (140, 0), (145, 1), (150, 0), (155, 0), (160, 0), (165, 1), (170, 1), (175, 1), (180, 1), (185, 1), (190, 1), (195, 1), (200, 0), (205, 0), (210, 0), (215, 0), (220, 0), (225, 1), (230, 1), (235, 1), (240, 1), (245, 1), (250, 1), (255, 0), (260, 0), (265, 0), (270, 1), (275, 0), (280, 0), (285, 0), (290, 0), (295, 0), (300, 0), (305, 0), (310, 0), (315, 1), (320, 0), (325, 0), (330, 1), (335, 1), (340, 1), (345, 0), (350, 0), (355, 1), (360, 1), (365, 1), (370, 0), (375, 0), (380, 1), (385, 0), (390, 1), (395, 1), (400, 0), (405, 0), (410, 1), (415, 1), (420, 0), (425, 0), (430, 1), (435, 1), (440, 1), (445, 1), (450, 1), (455, 1), (460, 1), (465, 0), (470, 0), (475, 0), (480, 0), (485, 0), (490, 1), (495, 1), (500, 1), (505, 0), (510, 0), (515, 0), (520, 0), (525, 0), (530, 0), (535, 1), (540, 1), (545, 0), (550, 1), (555, 1), (560, 1), (565, 1), (570, 1), (575, 0), (580, 0), (585, 0), (590, 0), (595, 0), (600, 0), (605, 0), (610, 0), (615, 0), (620, 1), (625, 1), (630, 1), (635, 1), (640, 1), (645, 1), (650, 0), (655, 0), (660, 1), (665, 0), (670, 0), (675, 1), (680, 0), (685, 0), (690, 1), (695, 1), (700, 1), (705, 1), (710, 0), (715, 1), (720, 1), (725, 1), (730, 0), (735, 0), (740, 1), (745, 1), (750, 1), (755, 0), (760, 0), (765, 1), (770, 0), (775, 1), (780, 1), (785, 0), (790, 1), (795, 1), (800, 1), (805, 1), (810, 1), (815, 1), (820, 0), (825, 0), (830, 1), (835, 1), (840, 1), (845, 0), (850, 0), (855, 0), (860, 1), (865, 0), (870, 0), (875, 0), (880, 0), (885, 0), (890, 0), (895, 1), (900, 1), (905, 1), (910, 1), (915, 1), (920, 0), (925, 0), (930, 1), (935, 0), (940, 1), (945, 1), (950, 1), (955, 1), (960, 0), (965, 0), (970, 0), (975, 0), (980, 0), (985, 0), (990, 0), (995, 1), (1000, 1), (1005, 1), (1010, 1), (1015, 1), (1020, 0), (1025, 0)]
Va0_1  a0_1  0 PWL (0n 0.0v 4.745n 0.0v 4.755n 0.0v 9.745n 0.0v 9.755n 1.1v 14.745n 1.1v 14.755n 0.0v 19.745n 0.0v 19.755n 0.0v 24.745n 0.0v 24.755n 1.1v 29.745n 1.1v 29.755n 1.1v 34.745n 1.1v 34.755n 1.1v 39.745n 1.1v 39.755n 1.1v 44.745n 1.1v 44.755n 1.1v 49.745n 1.1v 49.755n 0.0v 54.745n 0.0v 54.755n 1.1v 59.745n 1.1v 59.755n 0.0v 64.745n 0.0v 64.755n 1.1v 69.745n 1.1v 69.755n 1.1v 74.745n 1.1v 74.755n 1.1v 79.745n 1.1v 79.755n 0.0v 84.745n 0.0v 84.755n 0.0v 89.745n 0.0v 89.755n 0.0v 94.745n 0.0v 94.755n 0.0v 99.745n 0.0v 99.755n 0.0v 104.745n 0.0v 104.755n 0.0v 109.745n 0.0v 109.755n 0.0v 114.745n 0.0v 114.755n 0.0v 119.745n 0.0v 119.755n 0.0v 124.745n 0.0v 124.755n 0.0v 129.745n 0.0v 129.755n 1.1v 134.745n 1.1v 134.755n 0.0v 139.745n 0.0v 139.755n 0.0v 144.745n 0.0v 144.755n 1.1v 149.745n 1.1v 149.755n 0.0v 154.745n 0.0v 154.755n 0.0v 159.745n 0.0v 159.755n 0.0v 164.745n 0.0v 164.755n 1.1v 169.745n 1.1v 169.755n 1.1v 174.745n 1.1v 174.755n 1.1v 179.745n 1.1v 179.755n 1.1v 184.745n 1.1v 184.755n 1.1v 189.745n 1.1v 189.755n 1.1v 194.745n 1.1v 194.755n 1.1v 199.745n 1.1v 199.755n 0.0v 204.745n 0.0v 204.755n 0.0v 209.745n 0.0v 209.755n 0.0v 214.745n 0.0v 214.755n 0.0v 219.745n 0.0v 219.755n 0.0v 224.745n 0.0v 224.755n 1.1v 229.745n 1.1v 229.755n 1.1v 234.745n 1.1v 234.755n 1.1v 239.745n 1.1v 239.755n 1.1v 244.745n 1.1v 244.755n 1.1v 249.745n 1.1v 249.755n 1.1v 254.745n 1.1v 254.755n 0.0v 259.745n 0.0v 259.755n 0.0v 264.745n 0.0v 264.755n 0.0v 269.745n 0.0v 269.755n 1.1v 274.745n 1.1v 274.755n 0.0v 279.745n 0.0v 279.755n 0.0v 284.745n 0.0v 284.755n 0.0v 289.745n 0.0v 289.755n 0.0v 294.745n 0.0v 294.755n 0.0v 299.745n 0.0v 299.755n 0.0v 304.745n 0.0v 304.755n 0.0v 309.745n 0.0v 309.755n 0.0v 314.745n 0.0v 314.755n 1.1v 319.745n 1.1v 319.755n 0.0v 324.745n 0.0v 324.755n 0.0v 329.745n 0.0v 329.755n 1.1v 334.745n 1.1v 334.755n 1.1v 339.745n 1.1v 339.755n 1.1v 344.745n 1.1v 344.755n 0.0v 349.745n 0.0v 349.755n 0.0v 354.745n 0.0v 354.755n 1.1v 359.745n 1.1v 359.755n 1.1v 364.745n 1.1v 364.755n 1.1v 369.745n 1.1v 369.755n 0.0v 374.745n 0.0v 374.755n 0.0v 379.745n 0.0v 379.755n 1.1v 384.745n 1.1v 384.755n 0.0v 389.745n 0.0v 389.755n 1.1v 394.745n 1.1v 394.755n 1.1v 399.745n 1.1v 399.755n 0.0v 404.745n 0.0v 404.755n 0.0v 409.745n 0.0v 409.755n 1.1v 414.745n 1.1v 414.755n 1.1v 419.745n 1.1v 419.755n 0.0v 424.745n 0.0v 424.755n 0.0v 429.745n 0.0v 429.755n 1.1v 434.745n 1.1v 434.755n 1.1v 439.745n 1.1v 439.755n 1.1v 444.745n 1.1v 444.755n 1.1v 449.745n 1.1v 449.755n 1.1v 454.745n 1.1v 454.755n 1.1v 459.745n 1.1v 459.755n 1.1v 464.745n 1.1v 464.755n 0.0v 469.745n 0.0v 469.755n 0.0v 474.745n 0.0v 474.755n 0.0v 479.745n 0.0v 479.755n 0.0v 484.745n 0.0v 484.755n 0.0v 489.745n 0.0v 489.755n 1.1v 494.745n 1.1v 494.755n 1.1v 499.745n 1.1v 499.755n 1.1v 504.745n 1.1v 504.755n 0.0v 509.745n 0.0v 509.755n 0.0v 514.745n 0.0v 514.755n 0.0v 519.745n 0.0v 519.755n 0.0v 524.745n 0.0v 524.755n 0.0v 529.745n 0.0v 529.755n 0.0v 534.745n 0.0v 534.755n 1.1v 539.745n 1.1v 539.755n 1.1v 544.745n 1.1v 544.755n 0.0v 549.745n 0.0v 549.755n 1.1v 554.745n 1.1v 554.755n 1.1v 559.745n 1.1v 559.755n 1.1v 564.745n 1.1v 564.755n 1.1v 569.745n 1.1v 569.755n 1.1v 574.745n 1.1v 574.755n 0.0v 579.745n 0.0v 579.755n 0.0v 584.745n 0.0v 584.755n 0.0v 589.745n 0.0v 589.755n 0.0v 594.745n 0.0v 594.755n 0.0v 599.745n 0.0v 599.755n 0.0v 604.745n 0.0v 604.755n 0.0v 609.745n 0.0v 609.755n 0.0v 614.745n 0.0v 614.755n 0.0v 619.745n 0.0v 619.755n 1.1v 624.745n 1.1v 624.755n 1.1v 629.745n 1.1v 629.755n 1.1v 634.745n 1.1v 634.755n 1.1v 639.745n 1.1v 639.755n 1.1v 644.745n 1.1v 644.755n 1.1v 649.745n 1.1v 649.755n 0.0v 654.745n 0.0v 654.755n 0.0v 659.745n 0.0v 659.755n 1.1v 664.745n 1.1v 664.755n 0.0v 669.745n 0.0v 669.755n 0.0v 674.745n 0.0v 674.755n 1.1v 679.745n 1.1v 679.755n 0.0v 684.745n 0.0v 684.755n 0.0v 689.745n 0.0v 689.755n 1.1v 694.745n 1.1v 694.755n 1.1v 699.745n 1.1v 699.755n 1.1v 704.745n 1.1v 704.755n 1.1v 709.745n 1.1v 709.755n 0.0v 714.745n 0.0v 714.755n 1.1v 719.745n 1.1v 719.755n 1.1v 724.745n 1.1v 724.755n 1.1v 729.745n 1.1v 729.755n 0.0v 734.745n 0.0v 734.755n 0.0v 739.745n 0.0v 739.755n 1.1v 744.745n 1.1v 744.755n 1.1v 749.745n 1.1v 749.755n 1.1v 754.745n 1.1v 754.755n 0.0v 759.745n 0.0v 759.755n 0.0v 764.745n 0.0v 764.755n 1.1v 769.745n 1.1v 769.755n 0.0v 774.745n 0.0v 774.755n 1.1v 779.745n 1.1v 779.755n 1.1v 784.745n 1.1v 784.755n 0.0v 789.745n 0.0v 789.755n 1.1v 794.745n 1.1v 794.755n 1.1v 799.745n 1.1v 799.755n 1.1v 804.745n 1.1v 804.755n 1.1v 809.745n 1.1v 809.755n 1.1v 814.745n 1.1v 814.755n 1.1v 819.745n 1.1v 819.755n 0.0v 824.745n 0.0v 824.755n 0.0v 829.745n 0.0v 829.755n 1.1v 834.745n 1.1v 834.755n 1.1v 839.745n 1.1v 839.755n 1.1v 844.745n 1.1v 844.755n 0.0v 849.745n 0.0v 849.755n 0.0v 854.745n 0.0v 854.755n 0.0v 859.745n 0.0v 859.755n 1.1v 864.745n 1.1v 864.755n 0.0v 869.745n 0.0v 869.755n 0.0v 874.745n 0.0v 874.755n 0.0v 879.745n 0.0v 879.755n 0.0v 884.745n 0.0v 884.755n 0.0v 889.745n 0.0v 889.755n 0.0v 894.745n 0.0v 894.755n 1.1v 899.745n 1.1v 899.755n 1.1v 904.745n 1.1v 904.755n 1.1v 909.745n 1.1v 909.755n 1.1v 914.745n 1.1v 914.755n 1.1v 919.745n 1.1v 919.755n 0.0v 924.745n 0.0v 924.755n 0.0v 929.745n 0.0v 929.755n 1.1v 934.745n 1.1v 934.755n 0.0v 939.745n 0.0v 939.755n 1.1v 944.745n 1.1v 944.755n 1.1v 949.745n 1.1v 949.755n 1.1v 954.745n 1.1v 954.755n 1.1v 959.745n 1.1v 959.755n 0.0v 964.745n 0.0v 964.755n 0.0v 969.745n 0.0v 969.755n 0.0v 974.745n 0.0v 974.755n 0.0v 979.745n 0.0v 979.755n 0.0v 984.745n 0.0v 984.755n 0.0v 989.745n 0.0v 989.755n 0.0v 994.745n 0.0v 994.755n 1.1v 999.745n 1.1v 999.755n 1.1v 1004.745n 1.1v 1004.755n 1.1v 1009.745n 1.1v 1009.755n 1.1v 1014.745n 1.1v 1014.755n 1.1v 1019.745n 1.1v 1019.755n 0.0v 1024.745n 0.0v 1024.755n 0.0v )
* (time, data): [(0, 0), (5, 1), (10, 1), (15, 0), (20, 1), (25, 1), (30, 0), (35, 0), (40, 0), (45, 0), (50, 0), (55, 0), (60, 0), (65, 1), (70, 1), (75, 1), (80, 1), (85, 1), (90, 0), (95, 1), (100, 0), (105, 0), (110, 0), (115, 1), (120, 0), (125, 0), (130, 0), (135, 0), (140, 1), (145, 0), (150, 1), (155, 0), (160, 0), (165, 1), (170, 1), (175, 1), (180, 1), (185, 0), (190, 1), (195, 0), (200, 1), (205, 0), (210, 0), (215, 0), (220, 1), (225, 0), (230, 0), (235, 0), (240, 0), (245, 0), (250, 1), (255, 1), (260, 1), (265, 0), (270, 1), (275, 1), (280, 0), (285, 0), (290, 1), (295, 1), (300, 1), (305, 0), (310, 0), (315, 0), (320, 0), (325, 0), (330, 1), (335, 1), (340, 0), (345, 1), (350, 1), (355, 0), (360, 0), (365, 0), (370, 1), (375, 0), (380, 0), (385, 1), (390, 0), (395, 0), (400, 0), (405, 0), (410, 1), (415, 0), (420, 1), (425, 1), (430, 0), (435, 1), (440, 1), (445, 1), (450, 1), (455, 0), (460, 0), (465, 1), (470, 0), (475, 1), (480, 1), (485, 1), (490, 0), (495, 0), (500, 0), (505, 1), (510, 0), (515, 0), (520, 1), (525, 1), (530, 0), (535, 0), (540, 0), (545, 1), (550, 0), (555, 1), (560, 0), (565, 0), (570, 1), (575, 1), (580, 1), (585, 0), (590, 1), (595, 1), (600, 1), (605, 1), (610, 1), (615, 1), (620, 0), (625, 1), (630, 1), (635, 1), (640, 0), (645, 0), (650, 1), (655, 0), (660, 0), (665, 0), (670, 0), (675, 0), (680, 1), (685, 0), (690, 0), (695, 0), (700, 0), (705, 0), (710, 0), (715, 1), (720, 0), (725, 0), (730, 0), (735, 1), (740, 0), (745, 0), (750, 0), (755, 0), (760, 1), (765, 0), (770, 1), (775, 0), (780, 0), (785, 0), (790, 0), (795, 0), (800, 0), (805, 0), (810, 0), (815, 0), (820, 0), (825, 0), (830, 0), (835, 0), (840, 0), (845, 0), (850, 1), (855, 1), (860, 0), (865, 0), (870, 0), (875, 1), (880, 1), (885, 1), (890, 1), (895, 0), (900, 0), (905, 0), (910, 1), (915, 1), (920, 0), (925, 0), (930, 0), (935, 1), (940, 0), (945, 0), (950, 0), (955, 0), (960, 0), (965, 0), (970, 0), (975, 1), (980, 1), (985, 1), (990, 1), (995, 1), (1000, 1), (1005, 1), (1010, 1), (1015, 1), (1020, 0), (1025, 0)]
Va0_2  a0_2  0 PWL (0n 0.0v 4.745n 0.0v 4.755n 1.1v 9.745n 1.1v 9.755n 1.1v 14.745n 1.1v 14.755n 0.0v 19.745n 0.0v 19.755n 1.1v 24.745n 1.1v 24.755n 1.1v 29.745n 1.1v 29.755n 0.0v 34.745n 0.0v 34.755n 0.0v 39.745n 0.0v 39.755n 0.0v 44.745n 0.0v 44.755n 0.0v 49.745n 0.0v 49.755n 0.0v 54.745n 0.0v 54.755n 0.0v 59.745n 0.0v 59.755n 0.0v 64.745n 0.0v 64.755n 1.1v 69.745n 1.1v 69.755n 1.1v 74.745n 1.1v 74.755n 1.1v 79.745n 1.1v 79.755n 1.1v 84.745n 1.1v 84.755n 1.1v 89.745n 1.1v 89.755n 0.0v 94.745n 0.0v 94.755n 1.1v 99.745n 1.1v 99.755n 0.0v 104.745n 0.0v 104.755n 0.0v 109.745n 0.0v 109.755n 0.0v 114.745n 0.0v 114.755n 1.1v 119.745n 1.1v 119.755n 0.0v 124.745n 0.0v 124.755n 0.0v 129.745n 0.0v 129.755n 0.0v 134.745n 0.0v 134.755n 0.0v 139.745n 0.0v 139.755n 1.1v 144.745n 1.1v 144.755n 0.0v 149.745n 0.0v 149.755n 1.1v 154.745n 1.1v 154.755n 0.0v 159.745n 0.0v 159.755n 0.0v 164.745n 0.0v 164.755n 1.1v 169.745n 1.1v 169.755n 1.1v 174.745n 1.1v 174.755n 1.1v 179.745n 1.1v 179.755n 1.1v 184.745n 1.1v 184.755n 0.0v 189.745n 0.0v 189.755n 1.1v 194.745n 1.1v 194.755n 0.0v 199.745n 0.0v 199.755n 1.1v 204.745n 1.1v 204.755n 0.0v 209.745n 0.0v 209.755n 0.0v 214.745n 0.0v 214.755n 0.0v 219.745n 0.0v 219.755n 1.1v 224.745n 1.1v 224.755n 0.0v 229.745n 0.0v 229.755n 0.0v 234.745n 0.0v 234.755n 0.0v 239.745n 0.0v 239.755n 0.0v 244.745n 0.0v 244.755n 0.0v 249.745n 0.0v 249.755n 1.1v 254.745n 1.1v 254.755n 1.1v 259.745n 1.1v 259.755n 1.1v 264.745n 1.1v 264.755n 0.0v 269.745n 0.0v 269.755n 1.1v 274.745n 1.1v 274.755n 1.1v 279.745n 1.1v 279.755n 0.0v 284.745n 0.0v 284.755n 0.0v 289.745n 0.0v 289.755n 1.1v 294.745n 1.1v 294.755n 1.1v 299.745n 1.1v 299.755n 1.1v 304.745n 1.1v 304.755n 0.0v 309.745n 0.0v 309.755n 0.0v 314.745n 0.0v 314.755n 0.0v 319.745n 0.0v 319.755n 0.0v 324.745n 0.0v 324.755n 0.0v 329.745n 0.0v 329.755n 1.1v 334.745n 1.1v 334.755n 1.1v 339.745n 1.1v 339.755n 0.0v 344.745n 0.0v 344.755n 1.1v 349.745n 1.1v 349.755n 1.1v 354.745n 1.1v 354.755n 0.0v 359.745n 0.0v 359.755n 0.0v 364.745n 0.0v 364.755n 0.0v 369.745n 0.0v 369.755n 1.1v 374.745n 1.1v 374.755n 0.0v 379.745n 0.0v 379.755n 0.0v 384.745n 0.0v 384.755n 1.1v 389.745n 1.1v 389.755n 0.0v 394.745n 0.0v 394.755n 0.0v 399.745n 0.0v 399.755n 0.0v 404.745n 0.0v 404.755n 0.0v 409.745n 0.0v 409.755n 1.1v 414.745n 1.1v 414.755n 0.0v 419.745n 0.0v 419.755n 1.1v 424.745n 1.1v 424.755n 1.1v 429.745n 1.1v 429.755n 0.0v 434.745n 0.0v 434.755n 1.1v 439.745n 1.1v 439.755n 1.1v 444.745n 1.1v 444.755n 1.1v 449.745n 1.1v 449.755n 1.1v 454.745n 1.1v 454.755n 0.0v 459.745n 0.0v 459.755n 0.0v 464.745n 0.0v 464.755n 1.1v 469.745n 1.1v 469.755n 0.0v 474.745n 0.0v 474.755n 1.1v 479.745n 1.1v 479.755n 1.1v 484.745n 1.1v 484.755n 1.1v 489.745n 1.1v 489.755n 0.0v 494.745n 0.0v 494.755n 0.0v 499.745n 0.0v 499.755n 0.0v 504.745n 0.0v 504.755n 1.1v 509.745n 1.1v 509.755n 0.0v 514.745n 0.0v 514.755n 0.0v 519.745n 0.0v 519.755n 1.1v 524.745n 1.1v 524.755n 1.1v 529.745n 1.1v 529.755n 0.0v 534.745n 0.0v 534.755n 0.0v 539.745n 0.0v 539.755n 0.0v 544.745n 0.0v 544.755n 1.1v 549.745n 1.1v 549.755n 0.0v 554.745n 0.0v 554.755n 1.1v 559.745n 1.1v 559.755n 0.0v 564.745n 0.0v 564.755n 0.0v 569.745n 0.0v 569.755n 1.1v 574.745n 1.1v 574.755n 1.1v 579.745n 1.1v 579.755n 1.1v 584.745n 1.1v 584.755n 0.0v 589.745n 0.0v 589.755n 1.1v 594.745n 1.1v 594.755n 1.1v 599.745n 1.1v 599.755n 1.1v 604.745n 1.1v 604.755n 1.1v 609.745n 1.1v 609.755n 1.1v 614.745n 1.1v 614.755n 1.1v 619.745n 1.1v 619.755n 0.0v 624.745n 0.0v 624.755n 1.1v 629.745n 1.1v 629.755n 1.1v 634.745n 1.1v 634.755n 1.1v 639.745n 1.1v 639.755n 0.0v 644.745n 0.0v 644.755n 0.0v 649.745n 0.0v 649.755n 1.1v 654.745n 1.1v 654.755n 0.0v 659.745n 0.0v 659.755n 0.0v 664.745n 0.0v 664.755n 0.0v 669.745n 0.0v 669.755n 0.0v 674.745n 0.0v 674.755n 0.0v 679.745n 0.0v 679.755n 1.1v 684.745n 1.1v 684.755n 0.0v 689.745n 0.0v 689.755n 0.0v 694.745n 0.0v 694.755n 0.0v 699.745n 0.0v 699.755n 0.0v 704.745n 0.0v 704.755n 0.0v 709.745n 0.0v 709.755n 0.0v 714.745n 0.0v 714.755n 1.1v 719.745n 1.1v 719.755n 0.0v 724.745n 0.0v 724.755n 0.0v 729.745n 0.0v 729.755n 0.0v 734.745n 0.0v 734.755n 1.1v 739.745n 1.1v 739.755n 0.0v 744.745n 0.0v 744.755n 0.0v 749.745n 0.0v 749.755n 0.0v 754.745n 0.0v 754.755n 0.0v 759.745n 0.0v 759.755n 1.1v 764.745n 1.1v 764.755n 0.0v 769.745n 0.0v 769.755n 1.1v 774.745n 1.1v 774.755n 0.0v 779.745n 0.0v 779.755n 0.0v 784.745n 0.0v 784.755n 0.0v 789.745n 0.0v 789.755n 0.0v 794.745n 0.0v 794.755n 0.0v 799.745n 0.0v 799.755n 0.0v 804.745n 0.0v 804.755n 0.0v 809.745n 0.0v 809.755n 0.0v 814.745n 0.0v 814.755n 0.0v 819.745n 0.0v 819.755n 0.0v 824.745n 0.0v 824.755n 0.0v 829.745n 0.0v 829.755n 0.0v 834.745n 0.0v 834.755n 0.0v 839.745n 0.0v 839.755n 0.0v 844.745n 0.0v 844.755n 0.0v 849.745n 0.0v 849.755n 1.1v 854.745n 1.1v 854.755n 1.1v 859.745n 1.1v 859.755n 0.0v 864.745n 0.0v 864.755n 0.0v 869.745n 0.0v 869.755n 0.0v 874.745n 0.0v 874.755n 1.1v 879.745n 1.1v 879.755n 1.1v 884.745n 1.1v 884.755n 1.1v 889.745n 1.1v 889.755n 1.1v 894.745n 1.1v 894.755n 0.0v 899.745n 0.0v 899.755n 0.0v 904.745n 0.0v 904.755n 0.0v 909.745n 0.0v 909.755n 1.1v 914.745n 1.1v 914.755n 1.1v 919.745n 1.1v 919.755n 0.0v 924.745n 0.0v 924.755n 0.0v 929.745n 0.0v 929.755n 0.0v 934.745n 0.0v 934.755n 1.1v 939.745n 1.1v 939.755n 0.0v 944.745n 0.0v 944.755n 0.0v 949.745n 0.0v 949.755n 0.0v 954.745n 0.0v 954.755n 0.0v 959.745n 0.0v 959.755n 0.0v 964.745n 0.0v 964.755n 0.0v 969.745n 0.0v 969.755n 0.0v 974.745n 0.0v 974.755n 1.1v 979.745n 1.1v 979.755n 1.1v 984.745n 1.1v 984.755n 1.1v 989.745n 1.1v 989.755n 1.1v 994.745n 1.1v 994.755n 1.1v 999.745n 1.1v 999.755n 1.1v 1004.745n 1.1v 1004.755n 1.1v 1009.745n 1.1v 1009.755n 1.1v 1014.745n 1.1v 1014.755n 1.1v 1019.745n 1.1v 1019.755n 0.0v 1024.745n 0.0v 1024.755n 0.0v )
* (time, data): [(0, 0), (5, 1), (10, 1), (15, 0), (20, 1), (25, 1), (30, 0), (35, 0), (40, 0), (45, 0), (50, 0), (55, 0), (60, 0), (65, 1), (70, 1), (75, 1), (80, 1), (85, 1), (90, 0), (95, 1), (100, 0), (105, 0), (110, 0), (115, 1), (120, 0), (125, 0), (130, 0), (135, 0), (140, 1), (145, 0), (150, 1), (155, 0), (160, 0), (165, 1), (170, 1), (175, 1), (180, 1), (185, 0), (190, 1), (195, 0), (200, 1), (205, 0), (210, 0), (215, 0), (220, 1), (225, 1), (230, 0), (235, 0), (240, 0), (245, 0), (250, 1), (255, 1), (260, 1), (265, 0), (270, 1), (275, 1), (280, 0), (285, 0), (290, 1), (295, 1), (300, 1), (305, 0), (310, 0), (315, 0), (320, 0), (325, 0), (330, 1), (335, 1), (340, 0), (345, 1), (350, 1), (355, 0), (360, 1), (365, 1), (370, 1), (375, 0), (380, 0), (385, 1), (390, 1), (395, 1), (400, 0), (405, 0), (410, 1), (415, 0), (420, 1), (425, 1), (430, 1), (435, 1), (440, 1), (445, 1), (450, 1), (455, 1), (460, 1), (465, 1), (470, 0), (475, 1), (480, 1), (485, 1), (490, 0), (495, 0), (500, 0), (505, 1), (510, 0), (515, 0), (520, 1), (525, 1), (530, 0), (535, 1), (540, 1), (545, 1), (550, 0), (555, 1), (560, 1), (565, 0), (570, 1), (575, 1), (580, 1), (585, 0), (590, 1), (595, 1), (600, 1), (605, 1), (610, 1), (615, 1), (620, 0), (625, 1), (630, 1), (635, 1), (640, 1), (645, 0), (650, 1), (655, 0), (660, 0), (665, 0), (670, 0), (675, 0), (680, 1), (685, 0), (690, 0), (695, 0), (700, 0), (705, 0), (710, 0), (715, 1), (720, 1), (725, 1), (730, 0), (735, 1), (740, 1), (745, 1), (750, 1), (755, 0), (760, 1), (765, 1), (770, 1), (775, 0), (780, 0), (785, 0), (790, 0), (795, 0), (800, 0), (805, 1), (810, 0), (815, 0), (820, 0), (825, 0), (830, 0), (835, 0), (840, 0), (845, 0), (850, 1), (855, 1), (860, 1), (865, 0), (870, 0), (875, 1), (880, 1), (885, 1), (890, 1), (895, 0), (900, 1), (905, 1), (910, 1), (915, 1), (920, 0), (925, 0), (930, 1), (935, 1), (940, 1), (945, 1), (950, 1), (955, 1), (960, 0), (965, 0), (970, 0), (975, 1), (980, 1), (985, 1), (990, 1), (995, 1), (1000, 1), (1005, 1), (1010, 1), (1015, 1), (1020, 0), (1025, 0)]
Va0_3  a0_3  0 PWL (0n 0.0v 4.745n 0.0v 4.755n 1.1v 9.745n 1.1v 9.755n 1.1v 14.745n 1.1v 14.755n 0.0v 19.745n 0.0v 19.755n 1.1v 24.745n 1.1v 24.755n 1.1v 29.745n 1.1v 29.755n 0.0v 34.745n 0.0v 34.755n 0.0v 39.745n 0.0v 39.755n 0.0v 44.745n 0.0v 44.755n 0.0v 49.745n 0.0v 49.755n 0.0v 54.745n 0.0v 54.755n 0.0v 59.745n 0.0v 59.755n 0.0v 64.745n 0.0v 64.755n 1.1v 69.745n 1.1v 69.755n 1.1v 74.745n 1.1v 74.755n 1.1v 79.745n 1.1v 79.755n 1.1v 84.745n 1.1v 84.755n 1.1v 89.745n 1.1v 89.755n 0.0v 94.745n 0.0v 94.755n 1.1v 99.745n 1.1v 99.755n 0.0v 104.745n 0.0v 104.755n 0.0v 109.745n 0.0v 109.755n 0.0v 114.745n 0.0v 114.755n 1.1v 119.745n 1.1v 119.755n 0.0v 124.745n 0.0v 124.755n 0.0v 129.745n 0.0v 129.755n 0.0v 134.745n 0.0v 134.755n 0.0v 139.745n 0.0v 139.755n 1.1v 144.745n 1.1v 144.755n 0.0v 149.745n 0.0v 149.755n 1.1v 154.745n 1.1v 154.755n 0.0v 159.745n 0.0v 159.755n 0.0v 164.745n 0.0v 164.755n 1.1v 169.745n 1.1v 169.755n 1.1v 174.745n 1.1v 174.755n 1.1v 179.745n 1.1v 179.755n 1.1v 184.745n 1.1v 184.755n 0.0v 189.745n 0.0v 189.755n 1.1v 194.745n 1.1v 194.755n 0.0v 199.745n 0.0v 199.755n 1.1v 204.745n 1.1v 204.755n 0.0v 209.745n 0.0v 209.755n 0.0v 214.745n 0.0v 214.755n 0.0v 219.745n 0.0v 219.755n 1.1v 224.745n 1.1v 224.755n 1.1v 229.745n 1.1v 229.755n 0.0v 234.745n 0.0v 234.755n 0.0v 239.745n 0.0v 239.755n 0.0v 244.745n 0.0v 244.755n 0.0v 249.745n 0.0v 249.755n 1.1v 254.745n 1.1v 254.755n 1.1v 259.745n 1.1v 259.755n 1.1v 264.745n 1.1v 264.755n 0.0v 269.745n 0.0v 269.755n 1.1v 274.745n 1.1v 274.755n 1.1v 279.745n 1.1v 279.755n 0.0v 284.745n 0.0v 284.755n 0.0v 289.745n 0.0v 289.755n 1.1v 294.745n 1.1v 294.755n 1.1v 299.745n 1.1v 299.755n 1.1v 304.745n 1.1v 304.755n 0.0v 309.745n 0.0v 309.755n 0.0v 314.745n 0.0v 314.755n 0.0v 319.745n 0.0v 319.755n 0.0v 324.745n 0.0v 324.755n 0.0v 329.745n 0.0v 329.755n 1.1v 334.745n 1.1v 334.755n 1.1v 339.745n 1.1v 339.755n 0.0v 344.745n 0.0v 344.755n 1.1v 349.745n 1.1v 349.755n 1.1v 354.745n 1.1v 354.755n 0.0v 359.745n 0.0v 359.755n 1.1v 364.745n 1.1v 364.755n 1.1v 369.745n 1.1v 369.755n 1.1v 374.745n 1.1v 374.755n 0.0v 379.745n 0.0v 379.755n 0.0v 384.745n 0.0v 384.755n 1.1v 389.745n 1.1v 389.755n 1.1v 394.745n 1.1v 394.755n 1.1v 399.745n 1.1v 399.755n 0.0v 404.745n 0.0v 404.755n 0.0v 409.745n 0.0v 409.755n 1.1v 414.745n 1.1v 414.755n 0.0v 419.745n 0.0v 419.755n 1.1v 424.745n 1.1v 424.755n 1.1v 429.745n 1.1v 429.755n 1.1v 434.745n 1.1v 434.755n 1.1v 439.745n 1.1v 439.755n 1.1v 444.745n 1.1v 444.755n 1.1v 449.745n 1.1v 449.755n 1.1v 454.745n 1.1v 454.755n 1.1v 459.745n 1.1v 459.755n 1.1v 464.745n 1.1v 464.755n 1.1v 469.745n 1.1v 469.755n 0.0v 474.745n 0.0v 474.755n 1.1v 479.745n 1.1v 479.755n 1.1v 484.745n 1.1v 484.755n 1.1v 489.745n 1.1v 489.755n 0.0v 494.745n 0.0v 494.755n 0.0v 499.745n 0.0v 499.755n 0.0v 504.745n 0.0v 504.755n 1.1v 509.745n 1.1v 509.755n 0.0v 514.745n 0.0v 514.755n 0.0v 519.745n 0.0v 519.755n 1.1v 524.745n 1.1v 524.755n 1.1v 529.745n 1.1v 529.755n 0.0v 534.745n 0.0v 534.755n 1.1v 539.745n 1.1v 539.755n 1.1v 544.745n 1.1v 544.755n 1.1v 549.745n 1.1v 549.755n 0.0v 554.745n 0.0v 554.755n 1.1v 559.745n 1.1v 559.755n 1.1v 564.745n 1.1v 564.755n 0.0v 569.745n 0.0v 569.755n 1.1v 574.745n 1.1v 574.755n 1.1v 579.745n 1.1v 579.755n 1.1v 584.745n 1.1v 584.755n 0.0v 589.745n 0.0v 589.755n 1.1v 594.745n 1.1v 594.755n 1.1v 599.745n 1.1v 599.755n 1.1v 604.745n 1.1v 604.755n 1.1v 609.745n 1.1v 609.755n 1.1v 614.745n 1.1v 614.755n 1.1v 619.745n 1.1v 619.755n 0.0v 624.745n 0.0v 624.755n 1.1v 629.745n 1.1v 629.755n 1.1v 634.745n 1.1v 634.755n 1.1v 639.745n 1.1v 639.755n 1.1v 644.745n 1.1v 644.755n 0.0v 649.745n 0.0v 649.755n 1.1v 654.745n 1.1v 654.755n 0.0v 659.745n 0.0v 659.755n 0.0v 664.745n 0.0v 664.755n 0.0v 669.745n 0.0v 669.755n 0.0v 674.745n 0.0v 674.755n 0.0v 679.745n 0.0v 679.755n 1.1v 684.745n 1.1v 684.755n 0.0v 689.745n 0.0v 689.755n 0.0v 694.745n 0.0v 694.755n 0.0v 699.745n 0.0v 699.755n 0.0v 704.745n 0.0v 704.755n 0.0v 709.745n 0.0v 709.755n 0.0v 714.745n 0.0v 714.755n 1.1v 719.745n 1.1v 719.755n 1.1v 724.745n 1.1v 724.755n 1.1v 729.745n 1.1v 729.755n 0.0v 734.745n 0.0v 734.755n 1.1v 739.745n 1.1v 739.755n 1.1v 744.745n 1.1v 744.755n 1.1v 749.745n 1.1v 749.755n 1.1v 754.745n 1.1v 754.755n 0.0v 759.745n 0.0v 759.755n 1.1v 764.745n 1.1v 764.755n 1.1v 769.745n 1.1v 769.755n 1.1v 774.745n 1.1v 774.755n 0.0v 779.745n 0.0v 779.755n 0.0v 784.745n 0.0v 784.755n 0.0v 789.745n 0.0v 789.755n 0.0v 794.745n 0.0v 794.755n 0.0v 799.745n 0.0v 799.755n 0.0v 804.745n 0.0v 804.755n 1.1v 809.745n 1.1v 809.755n 0.0v 814.745n 0.0v 814.755n 0.0v 819.745n 0.0v 819.755n 0.0v 824.745n 0.0v 824.755n 0.0v 829.745n 0.0v 829.755n 0.0v 834.745n 0.0v 834.755n 0.0v 839.745n 0.0v 839.755n 0.0v 844.745n 0.0v 844.755n 0.0v 849.745n 0.0v 849.755n 1.1v 854.745n 1.1v 854.755n 1.1v 859.745n 1.1v 859.755n 1.1v 864.745n 1.1v 864.755n 0.0v 869.745n 0.0v 869.755n 0.0v 874.745n 0.0v 874.755n 1.1v 879.745n 1.1v 879.755n 1.1v 884.745n 1.1v 884.755n 1.1v 889.745n 1.1v 889.755n 1.1v 894.745n 1.1v 894.755n 0.0v 899.745n 0.0v 899.755n 1.1v 904.745n 1.1v 904.755n 1.1v 909.745n 1.1v 909.755n 1.1v 914.745n 1.1v 914.755n 1.1v 919.745n 1.1v 919.755n 0.0v 924.745n 0.0v 924.755n 0.0v 929.745n 0.0v 929.755n 1.1v 934.745n 1.1v 934.755n 1.1v 939.745n 1.1v 939.755n 1.1v 944.745n 1.1v 944.755n 1.1v 949.745n 1.1v 949.755n 1.1v 954.745n 1.1v 954.755n 1.1v 959.745n 1.1v 959.755n 0.0v 964.745n 0.0v 964.755n 0.0v 969.745n 0.0v 969.755n 0.0v 974.745n 0.0v 974.755n 1.1v 979.745n 1.1v 979.755n 1.1v 984.745n 1.1v 984.755n 1.1v 989.745n 1.1v 989.755n 1.1v 994.745n 1.1v 994.755n 1.1v 999.745n 1.1v 999.755n 1.1v 1004.745n 1.1v 1004.755n 1.1v 1009.745n 1.1v 1009.755n 1.1v 1014.745n 1.1v 1014.755n 1.1v 1019.745n 1.1v 1019.755n 0.0v 1024.745n 0.0v 1024.755n 0.0v )
* (time, data): [(0, 0), (5, 1), (10, 1), (15, 0), (20, 1), (25, 1), (30, 0), (35, 0), (40, 0), (45, 0), (50, 0), (55, 0), (60, 0), (65, 1), (70, 1), (75, 1), (80, 1), (85, 1), (90, 0), (95, 1), (100, 0), (105, 0), (110, 0), (115, 1), (120, 0), (125, 0), (130, 0), (135, 0), (140, 1), (145, 0), (150, 1), (155, 0), (160, 0), (165, 1), (170, 1), (175, 1), (180, 1), (185, 0), (190, 1), (195, 0), (200, 1), (205, 0), (210, 0), (215, 0), (220, 1), (225, 1), (230, 0), (235, 0), (240, 0), (245, 0), (250, 1), (255, 1), (260, 1), (265, 0), (270, 1), (275, 1), (280, 0), (285, 0), (290, 1), (295, 1), (300, 1), (305, 0), (310, 0), (315, 0), (320, 0), (325, 0), (330, 1), (335, 1), (340, 0), (345, 1), (350, 1), (355, 0), (360, 1), (365, 1), (370, 1), (375, 0), (380, 0), (385, 1), (390, 1), (395, 1), (400, 0), (405, 0), (410, 1), (415, 0), (420, 1), (425, 1), (430, 1), (435, 1), (440, 1), (445, 1), (450, 1), (455, 1), (460, 1), (465, 1), (470, 0), (475, 1), (480, 1), (485, 1), (490, 0), (495, 0), (500, 0), (505, 1), (510, 0), (515, 0), (520, 1), (525, 1), (530, 0), (535, 1), (540, 1), (545, 1), (550, 0), (555, 1), (560, 1), (565, 0), (570, 1), (575, 1), (580, 1), (585, 0), (590, 1), (595, 1), (600, 1), (605, 1), (610, 1), (615, 1), (620, 0), (625, 1), (630, 1), (635, 1), (640, 1), (645, 0), (650, 1), (655, 0), (660, 0), (665, 0), (670, 0), (675, 0), (680, 1), (685, 0), (690, 0), (695, 0), (700, 0), (705, 0), (710, 0), (715, 1), (720, 1), (725, 1), (730, 0), (735, 1), (740, 1), (745, 1), (750, 1), (755, 0), (760, 1), (765, 1), (770, 1), (775, 0), (780, 0), (785, 0), (790, 0), (795, 0), (800, 0), (805, 1), (810, 0), (815, 0), (820, 0), (825, 0), (830, 0), (835, 0), (840, 0), (845, 0), (850, 1), (855, 1), (860, 1), (865, 0), (870, 0), (875, 1), (880, 1), (885, 1), (890, 1), (895, 0), (900, 1), (905, 1), (910, 1), (915, 1), (920, 0), (925, 0), (930, 1), (935, 1), (940, 1), (945, 1), (950, 1), (955, 1), (960, 0), (965, 0), (970, 0), (975, 1), (980, 1), (985, 1), (990, 1), (995, 1), (1000, 1), (1005, 1), (1010, 1), (1015, 1), (1020, 0), (1025, 0)]
Va0_4  a0_4  0 PWL (0n 0.0v 4.745n 0.0v 4.755n 1.1v 9.745n 1.1v 9.755n 1.1v 14.745n 1.1v 14.755n 0.0v 19.745n 0.0v 19.755n 1.1v 24.745n 1.1v 24.755n 1.1v 29.745n 1.1v 29.755n 0.0v 34.745n 0.0v 34.755n 0.0v 39.745n 0.0v 39.755n 0.0v 44.745n 0.0v 44.755n 0.0v 49.745n 0.0v 49.755n 0.0v 54.745n 0.0v 54.755n 0.0v 59.745n 0.0v 59.755n 0.0v 64.745n 0.0v 64.755n 1.1v 69.745n 1.1v 69.755n 1.1v 74.745n 1.1v 74.755n 1.1v 79.745n 1.1v 79.755n 1.1v 84.745n 1.1v 84.755n 1.1v 89.745n 1.1v 89.755n 0.0v 94.745n 0.0v 94.755n 1.1v 99.745n 1.1v 99.755n 0.0v 104.745n 0.0v 104.755n 0.0v 109.745n 0.0v 109.755n 0.0v 114.745n 0.0v 114.755n 1.1v 119.745n 1.1v 119.755n 0.0v 124.745n 0.0v 124.755n 0.0v 129.745n 0.0v 129.755n 0.0v 134.745n 0.0v 134.755n 0.0v 139.745n 0.0v 139.755n 1.1v 144.745n 1.1v 144.755n 0.0v 149.745n 0.0v 149.755n 1.1v 154.745n 1.1v 154.755n 0.0v 159.745n 0.0v 159.755n 0.0v 164.745n 0.0v 164.755n 1.1v 169.745n 1.1v 169.755n 1.1v 174.745n 1.1v 174.755n 1.1v 179.745n 1.1v 179.755n 1.1v 184.745n 1.1v 184.755n 0.0v 189.745n 0.0v 189.755n 1.1v 194.745n 1.1v 194.755n 0.0v 199.745n 0.0v 199.755n 1.1v 204.745n 1.1v 204.755n 0.0v 209.745n 0.0v 209.755n 0.0v 214.745n 0.0v 214.755n 0.0v 219.745n 0.0v 219.755n 1.1v 224.745n 1.1v 224.755n 1.1v 229.745n 1.1v 229.755n 0.0v 234.745n 0.0v 234.755n 0.0v 239.745n 0.0v 239.755n 0.0v 244.745n 0.0v 244.755n 0.0v 249.745n 0.0v 249.755n 1.1v 254.745n 1.1v 254.755n 1.1v 259.745n 1.1v 259.755n 1.1v 264.745n 1.1v 264.755n 0.0v 269.745n 0.0v 269.755n 1.1v 274.745n 1.1v 274.755n 1.1v 279.745n 1.1v 279.755n 0.0v 284.745n 0.0v 284.755n 0.0v 289.745n 0.0v 289.755n 1.1v 294.745n 1.1v 294.755n 1.1v 299.745n 1.1v 299.755n 1.1v 304.745n 1.1v 304.755n 0.0v 309.745n 0.0v 309.755n 0.0v 314.745n 0.0v 314.755n 0.0v 319.745n 0.0v 319.755n 0.0v 324.745n 0.0v 324.755n 0.0v 329.745n 0.0v 329.755n 1.1v 334.745n 1.1v 334.755n 1.1v 339.745n 1.1v 339.755n 0.0v 344.745n 0.0v 344.755n 1.1v 349.745n 1.1v 349.755n 1.1v 354.745n 1.1v 354.755n 0.0v 359.745n 0.0v 359.755n 1.1v 364.745n 1.1v 364.755n 1.1v 369.745n 1.1v 369.755n 1.1v 374.745n 1.1v 374.755n 0.0v 379.745n 0.0v 379.755n 0.0v 384.745n 0.0v 384.755n 1.1v 389.745n 1.1v 389.755n 1.1v 394.745n 1.1v 394.755n 1.1v 399.745n 1.1v 399.755n 0.0v 404.745n 0.0v 404.755n 0.0v 409.745n 0.0v 409.755n 1.1v 414.745n 1.1v 414.755n 0.0v 419.745n 0.0v 419.755n 1.1v 424.745n 1.1v 424.755n 1.1v 429.745n 1.1v 429.755n 1.1v 434.745n 1.1v 434.755n 1.1v 439.745n 1.1v 439.755n 1.1v 444.745n 1.1v 444.755n 1.1v 449.745n 1.1v 449.755n 1.1v 454.745n 1.1v 454.755n 1.1v 459.745n 1.1v 459.755n 1.1v 464.745n 1.1v 464.755n 1.1v 469.745n 1.1v 469.755n 0.0v 474.745n 0.0v 474.755n 1.1v 479.745n 1.1v 479.755n 1.1v 484.745n 1.1v 484.755n 1.1v 489.745n 1.1v 489.755n 0.0v 494.745n 0.0v 494.755n 0.0v 499.745n 0.0v 499.755n 0.0v 504.745n 0.0v 504.755n 1.1v 509.745n 1.1v 509.755n 0.0v 514.745n 0.0v 514.755n 0.0v 519.745n 0.0v 519.755n 1.1v 524.745n 1.1v 524.755n 1.1v 529.745n 1.1v 529.755n 0.0v 534.745n 0.0v 534.755n 1.1v 539.745n 1.1v 539.755n 1.1v 544.745n 1.1v 544.755n 1.1v 549.745n 1.1v 549.755n 0.0v 554.745n 0.0v 554.755n 1.1v 559.745n 1.1v 559.755n 1.1v 564.745n 1.1v 564.755n 0.0v 569.745n 0.0v 569.755n 1.1v 574.745n 1.1v 574.755n 1.1v 579.745n 1.1v 579.755n 1.1v 584.745n 1.1v 584.755n 0.0v 589.745n 0.0v 589.755n 1.1v 594.745n 1.1v 594.755n 1.1v 599.745n 1.1v 599.755n 1.1v 604.745n 1.1v 604.755n 1.1v 609.745n 1.1v 609.755n 1.1v 614.745n 1.1v 614.755n 1.1v 619.745n 1.1v 619.755n 0.0v 624.745n 0.0v 624.755n 1.1v 629.745n 1.1v 629.755n 1.1v 634.745n 1.1v 634.755n 1.1v 639.745n 1.1v 639.755n 1.1v 644.745n 1.1v 644.755n 0.0v 649.745n 0.0v 649.755n 1.1v 654.745n 1.1v 654.755n 0.0v 659.745n 0.0v 659.755n 0.0v 664.745n 0.0v 664.755n 0.0v 669.745n 0.0v 669.755n 0.0v 674.745n 0.0v 674.755n 0.0v 679.745n 0.0v 679.755n 1.1v 684.745n 1.1v 684.755n 0.0v 689.745n 0.0v 689.755n 0.0v 694.745n 0.0v 694.755n 0.0v 699.745n 0.0v 699.755n 0.0v 704.745n 0.0v 704.755n 0.0v 709.745n 0.0v 709.755n 0.0v 714.745n 0.0v 714.755n 1.1v 719.745n 1.1v 719.755n 1.1v 724.745n 1.1v 724.755n 1.1v 729.745n 1.1v 729.755n 0.0v 734.745n 0.0v 734.755n 1.1v 739.745n 1.1v 739.755n 1.1v 744.745n 1.1v 744.755n 1.1v 749.745n 1.1v 749.755n 1.1v 754.745n 1.1v 754.755n 0.0v 759.745n 0.0v 759.755n 1.1v 764.745n 1.1v 764.755n 1.1v 769.745n 1.1v 769.755n 1.1v 774.745n 1.1v 774.755n 0.0v 779.745n 0.0v 779.755n 0.0v 784.745n 0.0v 784.755n 0.0v 789.745n 0.0v 789.755n 0.0v 794.745n 0.0v 794.755n 0.0v 799.745n 0.0v 799.755n 0.0v 804.745n 0.0v 804.755n 1.1v 809.745n 1.1v 809.755n 0.0v 814.745n 0.0v 814.755n 0.0v 819.745n 0.0v 819.755n 0.0v 824.745n 0.0v 824.755n 0.0v 829.745n 0.0v 829.755n 0.0v 834.745n 0.0v 834.755n 0.0v 839.745n 0.0v 839.755n 0.0v 844.745n 0.0v 844.755n 0.0v 849.745n 0.0v 849.755n 1.1v 854.745n 1.1v 854.755n 1.1v 859.745n 1.1v 859.755n 1.1v 864.745n 1.1v 864.755n 0.0v 869.745n 0.0v 869.755n 0.0v 874.745n 0.0v 874.755n 1.1v 879.745n 1.1v 879.755n 1.1v 884.745n 1.1v 884.755n 1.1v 889.745n 1.1v 889.755n 1.1v 894.745n 1.1v 894.755n 0.0v 899.745n 0.0v 899.755n 1.1v 904.745n 1.1v 904.755n 1.1v 909.745n 1.1v 909.755n 1.1v 914.745n 1.1v 914.755n 1.1v 919.745n 1.1v 919.755n 0.0v 924.745n 0.0v 924.755n 0.0v 929.745n 0.0v 929.755n 1.1v 934.745n 1.1v 934.755n 1.1v 939.745n 1.1v 939.755n 1.1v 944.745n 1.1v 944.755n 1.1v 949.745n 1.1v 949.755n 1.1v 954.745n 1.1v 954.755n 1.1v 959.745n 1.1v 959.755n 0.0v 964.745n 0.0v 964.755n 0.0v 969.745n 0.0v 969.755n 0.0v 974.745n 0.0v 974.755n 1.1v 979.745n 1.1v 979.755n 1.1v 984.745n 1.1v 984.755n 1.1v 989.745n 1.1v 989.755n 1.1v 994.745n 1.1v 994.755n 1.1v 999.745n 1.1v 999.755n 1.1v 1004.745n 1.1v 1004.755n 1.1v 1009.745n 1.1v 1009.755n 1.1v 1014.745n 1.1v 1014.755n 1.1v 1019.745n 1.1v 1019.755n 0.0v 1024.745n 0.0v 1024.755n 0.0v )
* (time, data): [(0, 0), (5, 1), (10, 1), (15, 0), (20, 1), (25, 1), (30, 0), (35, 0), (40, 0), (45, 0), (50, 0), (55, 0), (60, 0), (65, 1), (70, 1), (75, 1), (80, 1), (85, 1), (90, 0), (95, 1), (100, 0), (105, 0), (110, 0), (115, 1), (120, 0), (125, 0), (130, 0), (135, 0), (140, 1), (145, 0), (150, 1), (155, 0), (160, 0), (165, 1), (170, 1), (175, 1), (180, 1), (185, 0), (190, 1), (195, 0), (200, 1), (205, 0), (210, 0), (215, 0), (220, 1), (225, 1), (230, 0), (235, 0), (240, 0), (245, 0), (250, 1), (255, 1), (260, 1), (265, 0), (270, 1), (275, 1), (280, 0), (285, 0), (290, 1), (295, 1), (300, 1), (305, 0), (310, 0), (315, 0), (320, 0), (325, 0), (330, 1), (335, 1), (340, 0), (345, 1), (350, 1), (355, 0), (360, 1), (365, 1), (370, 1), (375, 0), (380, 0), (385, 1), (390, 1), (395, 1), (400, 0), (405, 0), (410, 1), (415, 0), (420, 1), (425, 1), (430, 1), (435, 1), (440, 1), (445, 1), (450, 1), (455, 1), (460, 1), (465, 1), (470, 0), (475, 1), (480, 1), (485, 1), (490, 0), (495, 0), (500, 0), (505, 1), (510, 0), (515, 0), (520, 1), (525, 1), (530, 0), (535, 1), (540, 1), (545, 1), (550, 0), (555, 1), (560, 1), (565, 0), (570, 1), (575, 1), (580, 1), (585, 0), (590, 1), (595, 1), (600, 1), (605, 1), (610, 1), (615, 1), (620, 0), (625, 1), (630, 1), (635, 1), (640, 1), (645, 0), (650, 1), (655, 0), (660, 0), (665, 0), (670, 0), (675, 0), (680, 1), (685, 0), (690, 0), (695, 0), (700, 0), (705, 0), (710, 0), (715, 1), (720, 1), (725, 1), (730, 0), (735, 1), (740, 1), (745, 1), (750, 1), (755, 0), (760, 1), (765, 1), (770, 1), (775, 0), (780, 0), (785, 0), (790, 0), (795, 0), (800, 0), (805, 1), (810, 0), (815, 0), (820, 0), (825, 0), (830, 0), (835, 0), (840, 0), (845, 0), (850, 1), (855, 1), (860, 1), (865, 0), (870, 0), (875, 1), (880, 1), (885, 1), (890, 1), (895, 0), (900, 1), (905, 1), (910, 1), (915, 1), (920, 0), (925, 0), (930, 1), (935, 1), (940, 1), (945, 1), (950, 1), (955, 1), (960, 0), (965, 0), (970, 0), (975, 1), (980, 1), (985, 1), (990, 1), (995, 1), (1000, 1), (1005, 1), (1010, 1), (1015, 1), (1020, 0), (1025, 0)]
Va0_5  a0_5  0 PWL (0n 0.0v 4.745n 0.0v 4.755n 1.1v 9.745n 1.1v 9.755n 1.1v 14.745n 1.1v 14.755n 0.0v 19.745n 0.0v 19.755n 1.1v 24.745n 1.1v 24.755n 1.1v 29.745n 1.1v 29.755n 0.0v 34.745n 0.0v 34.755n 0.0v 39.745n 0.0v 39.755n 0.0v 44.745n 0.0v 44.755n 0.0v 49.745n 0.0v 49.755n 0.0v 54.745n 0.0v 54.755n 0.0v 59.745n 0.0v 59.755n 0.0v 64.745n 0.0v 64.755n 1.1v 69.745n 1.1v 69.755n 1.1v 74.745n 1.1v 74.755n 1.1v 79.745n 1.1v 79.755n 1.1v 84.745n 1.1v 84.755n 1.1v 89.745n 1.1v 89.755n 0.0v 94.745n 0.0v 94.755n 1.1v 99.745n 1.1v 99.755n 0.0v 104.745n 0.0v 104.755n 0.0v 109.745n 0.0v 109.755n 0.0v 114.745n 0.0v 114.755n 1.1v 119.745n 1.1v 119.755n 0.0v 124.745n 0.0v 124.755n 0.0v 129.745n 0.0v 129.755n 0.0v 134.745n 0.0v 134.755n 0.0v 139.745n 0.0v 139.755n 1.1v 144.745n 1.1v 144.755n 0.0v 149.745n 0.0v 149.755n 1.1v 154.745n 1.1v 154.755n 0.0v 159.745n 0.0v 159.755n 0.0v 164.745n 0.0v 164.755n 1.1v 169.745n 1.1v 169.755n 1.1v 174.745n 1.1v 174.755n 1.1v 179.745n 1.1v 179.755n 1.1v 184.745n 1.1v 184.755n 0.0v 189.745n 0.0v 189.755n 1.1v 194.745n 1.1v 194.755n 0.0v 199.745n 0.0v 199.755n 1.1v 204.745n 1.1v 204.755n 0.0v 209.745n 0.0v 209.755n 0.0v 214.745n 0.0v 214.755n 0.0v 219.745n 0.0v 219.755n 1.1v 224.745n 1.1v 224.755n 1.1v 229.745n 1.1v 229.755n 0.0v 234.745n 0.0v 234.755n 0.0v 239.745n 0.0v 239.755n 0.0v 244.745n 0.0v 244.755n 0.0v 249.745n 0.0v 249.755n 1.1v 254.745n 1.1v 254.755n 1.1v 259.745n 1.1v 259.755n 1.1v 264.745n 1.1v 264.755n 0.0v 269.745n 0.0v 269.755n 1.1v 274.745n 1.1v 274.755n 1.1v 279.745n 1.1v 279.755n 0.0v 284.745n 0.0v 284.755n 0.0v 289.745n 0.0v 289.755n 1.1v 294.745n 1.1v 294.755n 1.1v 299.745n 1.1v 299.755n 1.1v 304.745n 1.1v 304.755n 0.0v 309.745n 0.0v 309.755n 0.0v 314.745n 0.0v 314.755n 0.0v 319.745n 0.0v 319.755n 0.0v 324.745n 0.0v 324.755n 0.0v 329.745n 0.0v 329.755n 1.1v 334.745n 1.1v 334.755n 1.1v 339.745n 1.1v 339.755n 0.0v 344.745n 0.0v 344.755n 1.1v 349.745n 1.1v 349.755n 1.1v 354.745n 1.1v 354.755n 0.0v 359.745n 0.0v 359.755n 1.1v 364.745n 1.1v 364.755n 1.1v 369.745n 1.1v 369.755n 1.1v 374.745n 1.1v 374.755n 0.0v 379.745n 0.0v 379.755n 0.0v 384.745n 0.0v 384.755n 1.1v 389.745n 1.1v 389.755n 1.1v 394.745n 1.1v 394.755n 1.1v 399.745n 1.1v 399.755n 0.0v 404.745n 0.0v 404.755n 0.0v 409.745n 0.0v 409.755n 1.1v 414.745n 1.1v 414.755n 0.0v 419.745n 0.0v 419.755n 1.1v 424.745n 1.1v 424.755n 1.1v 429.745n 1.1v 429.755n 1.1v 434.745n 1.1v 434.755n 1.1v 439.745n 1.1v 439.755n 1.1v 444.745n 1.1v 444.755n 1.1v 449.745n 1.1v 449.755n 1.1v 454.745n 1.1v 454.755n 1.1v 459.745n 1.1v 459.755n 1.1v 464.745n 1.1v 464.755n 1.1v 469.745n 1.1v 469.755n 0.0v 474.745n 0.0v 474.755n 1.1v 479.745n 1.1v 479.755n 1.1v 484.745n 1.1v 484.755n 1.1v 489.745n 1.1v 489.755n 0.0v 494.745n 0.0v 494.755n 0.0v 499.745n 0.0v 499.755n 0.0v 504.745n 0.0v 504.755n 1.1v 509.745n 1.1v 509.755n 0.0v 514.745n 0.0v 514.755n 0.0v 519.745n 0.0v 519.755n 1.1v 524.745n 1.1v 524.755n 1.1v 529.745n 1.1v 529.755n 0.0v 534.745n 0.0v 534.755n 1.1v 539.745n 1.1v 539.755n 1.1v 544.745n 1.1v 544.755n 1.1v 549.745n 1.1v 549.755n 0.0v 554.745n 0.0v 554.755n 1.1v 559.745n 1.1v 559.755n 1.1v 564.745n 1.1v 564.755n 0.0v 569.745n 0.0v 569.755n 1.1v 574.745n 1.1v 574.755n 1.1v 579.745n 1.1v 579.755n 1.1v 584.745n 1.1v 584.755n 0.0v 589.745n 0.0v 589.755n 1.1v 594.745n 1.1v 594.755n 1.1v 599.745n 1.1v 599.755n 1.1v 604.745n 1.1v 604.755n 1.1v 609.745n 1.1v 609.755n 1.1v 614.745n 1.1v 614.755n 1.1v 619.745n 1.1v 619.755n 0.0v 624.745n 0.0v 624.755n 1.1v 629.745n 1.1v 629.755n 1.1v 634.745n 1.1v 634.755n 1.1v 639.745n 1.1v 639.755n 1.1v 644.745n 1.1v 644.755n 0.0v 649.745n 0.0v 649.755n 1.1v 654.745n 1.1v 654.755n 0.0v 659.745n 0.0v 659.755n 0.0v 664.745n 0.0v 664.755n 0.0v 669.745n 0.0v 669.755n 0.0v 674.745n 0.0v 674.755n 0.0v 679.745n 0.0v 679.755n 1.1v 684.745n 1.1v 684.755n 0.0v 689.745n 0.0v 689.755n 0.0v 694.745n 0.0v 694.755n 0.0v 699.745n 0.0v 699.755n 0.0v 704.745n 0.0v 704.755n 0.0v 709.745n 0.0v 709.755n 0.0v 714.745n 0.0v 714.755n 1.1v 719.745n 1.1v 719.755n 1.1v 724.745n 1.1v 724.755n 1.1v 729.745n 1.1v 729.755n 0.0v 734.745n 0.0v 734.755n 1.1v 739.745n 1.1v 739.755n 1.1v 744.745n 1.1v 744.755n 1.1v 749.745n 1.1v 749.755n 1.1v 754.745n 1.1v 754.755n 0.0v 759.745n 0.0v 759.755n 1.1v 764.745n 1.1v 764.755n 1.1v 769.745n 1.1v 769.755n 1.1v 774.745n 1.1v 774.755n 0.0v 779.745n 0.0v 779.755n 0.0v 784.745n 0.0v 784.755n 0.0v 789.745n 0.0v 789.755n 0.0v 794.745n 0.0v 794.755n 0.0v 799.745n 0.0v 799.755n 0.0v 804.745n 0.0v 804.755n 1.1v 809.745n 1.1v 809.755n 0.0v 814.745n 0.0v 814.755n 0.0v 819.745n 0.0v 819.755n 0.0v 824.745n 0.0v 824.755n 0.0v 829.745n 0.0v 829.755n 0.0v 834.745n 0.0v 834.755n 0.0v 839.745n 0.0v 839.755n 0.0v 844.745n 0.0v 844.755n 0.0v 849.745n 0.0v 849.755n 1.1v 854.745n 1.1v 854.755n 1.1v 859.745n 1.1v 859.755n 1.1v 864.745n 1.1v 864.755n 0.0v 869.745n 0.0v 869.755n 0.0v 874.745n 0.0v 874.755n 1.1v 879.745n 1.1v 879.755n 1.1v 884.745n 1.1v 884.755n 1.1v 889.745n 1.1v 889.755n 1.1v 894.745n 1.1v 894.755n 0.0v 899.745n 0.0v 899.755n 1.1v 904.745n 1.1v 904.755n 1.1v 909.745n 1.1v 909.755n 1.1v 914.745n 1.1v 914.755n 1.1v 919.745n 1.1v 919.755n 0.0v 924.745n 0.0v 924.755n 0.0v 929.745n 0.0v 929.755n 1.1v 934.745n 1.1v 934.755n 1.1v 939.745n 1.1v 939.755n 1.1v 944.745n 1.1v 944.755n 1.1v 949.745n 1.1v 949.755n 1.1v 954.745n 1.1v 954.755n 1.1v 959.745n 1.1v 959.755n 0.0v 964.745n 0.0v 964.755n 0.0v 969.745n 0.0v 969.755n 0.0v 974.745n 0.0v 974.755n 1.1v 979.745n 1.1v 979.755n 1.1v 984.745n 1.1v 984.755n 1.1v 989.745n 1.1v 989.755n 1.1v 994.745n 1.1v 994.755n 1.1v 999.745n 1.1v 999.755n 1.1v 1004.745n 1.1v 1004.755n 1.1v 1009.745n 1.1v 1009.755n 1.1v 1014.745n 1.1v 1014.755n 1.1v 1019.745n 1.1v 1019.755n 0.0v 1024.745n 0.0v 1024.755n 0.0v )

 * Generation of control signals
* (time, data): [(0, 1), (5, 0), (10, 0), (15, 0), (20, 0), (25, 0), (30, 0), (35, 0), (40, 1), (45, 0), (50, 0), (55, 0), (60, 0), (65, 0), (70, 1), (75, 1), (80, 0), (85, 1), (90, 0), (95, 0), (100, 0), (105, 1), (110, 0), (115, 0), (120, 0), (125, 0), (130, 0), (135, 0), (140, 0), (145, 0), (150, 0), (155, 0), (160, 0), (165, 0), (170, 0), (175, 0), (180, 0), (185, 0), (190, 0), (195, 0), (200, 0), (205, 0), (210, 1), (215, 0), (220, 0), (225, 0), (230, 0), (235, 1), (240, 0), (245, 1), (250, 0), (255, 0), (260, 1), (265, 0), (270, 0), (275, 0), (280, 0), (285, 0), (290, 0), (295, 1), (300, 0), (305, 0), (310, 1), (315, 0), (320, 0), (325, 1), (330, 0), (335, 1), (340, 0), (345, 0), (350, 1), (355, 0), (360, 0), (365, 1), (370, 0), (375, 0), (380, 0), (385, 0), (390, 0), (395, 1), (400, 0), (405, 1), (410, 0), (415, 0), (420, 0), (425, 0), (430, 0), (435, 0), (440, 1), (445, 0), (450, 0), (455, 0), (460, 1), (465, 0), (470, 0), (475, 0), (480, 0), (485, 1), (490, 0), (495, 0), (500, 1), (505, 0), (510, 0), (515, 1), (520, 0), (525, 0), (530, 0), (535, 0), (540, 0), (545, 0), (550, 0), (555, 0), (560, 0), (565, 0), (570, 0), (575, 0), (580, 0), (585, 0), (590, 0), (595, 1), (600, 1), (605, 0), (610, 1), (615, 1), (620, 0), (625, 0), (630, 1), (635, 1), (640, 0), (645, 0), (650, 0), (655, 0), (660, 0), (665, 0), (670, 0), (675, 0), (680, 0), (685, 0), (690, 0), (695, 0), (700, 1), (705, 0), (710, 0), (715, 0), (720, 0), (725, 1), (730, 0), (735, 0), (740, 0), (745, 0), (750, 1), (755, 0), (760, 0), (765, 0), (770, 0), (775, 0), (780, 1), (785, 0), (790, 0), (795, 0), (800, 0), (805, 0), (810, 0), (815, 1), (820, 0), (825, 0), (830, 0), (835, 0), (840, 1), (845, 0), (850, 0), (855, 0), (860, 0), (865, 0), (870, 1), (875, 0), (880, 1), (885, 0), (890, 0), (895, 0), (900, 0), (905, 1), (910, 0), (915, 1), (920, 0), (925, 1), (930, 0), (935, 0), (940, 0), (945, 1), (950, 1), (955, 1), (960, 0), (965, 0), (970, 1), (975, 0), (980, 1), (985, 1), (990, 1), (995, 0), (1000, 1), (1005, 0), (1010, 0), (1015, 1), (1020, 0), (1025, 1)]
VCSB0 CSB0 0 PWL (0n 1.1v 4.745n 1.1v 4.755n 0.0v 9.745n 0.0v 9.755n 0.0v 14.745n 0.0v 14.755n 0.0v 19.745n 0.0v 19.755n 0.0v 24.745n 0.0v 24.755n 0.0v 29.745n 0.0v 29.755n 0.0v 34.745n 0.0v 34.755n 0.0v 39.745n 0.0v 39.755n 1.1v 44.745n 1.1v 44.755n 0.0v 49.745n 0.0v 49.755n 0.0v 54.745n 0.0v 54.755n 0.0v 59.745n 0.0v 59.755n 0.0v 64.745n 0.0v 64.755n 0.0v 69.745n 0.0v 69.755n 1.1v 74.745n 1.1v 74.755n 1.1v 79.745n 1.1v 79.755n 0.0v 84.745n 0.0v 84.755n 1.1v 89.745n 1.1v 89.755n 0.0v 94.745n 0.0v 94.755n 0.0v 99.745n 0.0v 99.755n 0.0v 104.745n 0.0v 104.755n 1.1v 109.745n 1.1v 109.755n 0.0v 114.745n 0.0v 114.755n 0.0v 119.745n 0.0v 119.755n 0.0v 124.745n 0.0v 124.755n 0.0v 129.745n 0.0v 129.755n 0.0v 134.745n 0.0v 134.755n 0.0v 139.745n 0.0v 139.755n 0.0v 144.745n 0.0v 144.755n 0.0v 149.745n 0.0v 149.755n 0.0v 154.745n 0.0v 154.755n 0.0v 159.745n 0.0v 159.755n 0.0v 164.745n 0.0v 164.755n 0.0v 169.745n 0.0v 169.755n 0.0v 174.745n 0.0v 174.755n 0.0v 179.745n 0.0v 179.755n 0.0v 184.745n 0.0v 184.755n 0.0v 189.745n 0.0v 189.755n 0.0v 194.745n 0.0v 194.755n 0.0v 199.745n 0.0v 199.755n 0.0v 204.745n 0.0v 204.755n 0.0v 209.745n 0.0v 209.755n 1.1v 214.745n 1.1v 214.755n 0.0v 219.745n 0.0v 219.755n 0.0v 224.745n 0.0v 224.755n 0.0v 229.745n 0.0v 229.755n 0.0v 234.745n 0.0v 234.755n 1.1v 239.745n 1.1v 239.755n 0.0v 244.745n 0.0v 244.755n 1.1v 249.745n 1.1v 249.755n 0.0v 254.745n 0.0v 254.755n 0.0v 259.745n 0.0v 259.755n 1.1v 264.745n 1.1v 264.755n 0.0v 269.745n 0.0v 269.755n 0.0v 274.745n 0.0v 274.755n 0.0v 279.745n 0.0v 279.755n 0.0v 284.745n 0.0v 284.755n 0.0v 289.745n 0.0v 289.755n 0.0v 294.745n 0.0v 294.755n 1.1v 299.745n 1.1v 299.755n 0.0v 304.745n 0.0v 304.755n 0.0v 309.745n 0.0v 309.755n 1.1v 314.745n 1.1v 314.755n 0.0v 319.745n 0.0v 319.755n 0.0v 324.745n 0.0v 324.755n 1.1v 329.745n 1.1v 329.755n 0.0v 334.745n 0.0v 334.755n 1.1v 339.745n 1.1v 339.755n 0.0v 344.745n 0.0v 344.755n 0.0v 349.745n 0.0v 349.755n 1.1v 354.745n 1.1v 354.755n 0.0v 359.745n 0.0v 359.755n 0.0v 364.745n 0.0v 364.755n 1.1v 369.745n 1.1v 369.755n 0.0v 374.745n 0.0v 374.755n 0.0v 379.745n 0.0v 379.755n 0.0v 384.745n 0.0v 384.755n 0.0v 389.745n 0.0v 389.755n 0.0v 394.745n 0.0v 394.755n 1.1v 399.745n 1.1v 399.755n 0.0v 404.745n 0.0v 404.755n 1.1v 409.745n 1.1v 409.755n 0.0v 414.745n 0.0v 414.755n 0.0v 419.745n 0.0v 419.755n 0.0v 424.745n 0.0v 424.755n 0.0v 429.745n 0.0v 429.755n 0.0v 434.745n 0.0v 434.755n 0.0v 439.745n 0.0v 439.755n 1.1v 444.745n 1.1v 444.755n 0.0v 449.745n 0.0v 449.755n 0.0v 454.745n 0.0v 454.755n 0.0v 459.745n 0.0v 459.755n 1.1v 464.745n 1.1v 464.755n 0.0v 469.745n 0.0v 469.755n 0.0v 474.745n 0.0v 474.755n 0.0v 479.745n 0.0v 479.755n 0.0v 484.745n 0.0v 484.755n 1.1v 489.745n 1.1v 489.755n 0.0v 494.745n 0.0v 494.755n 0.0v 499.745n 0.0v 499.755n 1.1v 504.745n 1.1v 504.755n 0.0v 509.745n 0.0v 509.755n 0.0v 514.745n 0.0v 514.755n 1.1v 519.745n 1.1v 519.755n 0.0v 524.745n 0.0v 524.755n 0.0v 529.745n 0.0v 529.755n 0.0v 534.745n 0.0v 534.755n 0.0v 539.745n 0.0v 539.755n 0.0v 544.745n 0.0v 544.755n 0.0v 549.745n 0.0v 549.755n 0.0v 554.745n 0.0v 554.755n 0.0v 559.745n 0.0v 559.755n 0.0v 564.745n 0.0v 564.755n 0.0v 569.745n 0.0v 569.755n 0.0v 574.745n 0.0v 574.755n 0.0v 579.745n 0.0v 579.755n 0.0v 584.745n 0.0v 584.755n 0.0v 589.745n 0.0v 589.755n 0.0v 594.745n 0.0v 594.755n 1.1v 599.745n 1.1v 599.755n 1.1v 604.745n 1.1v 604.755n 0.0v 609.745n 0.0v 609.755n 1.1v 614.745n 1.1v 614.755n 1.1v 619.745n 1.1v 619.755n 0.0v 624.745n 0.0v 624.755n 0.0v 629.745n 0.0v 629.755n 1.1v 634.745n 1.1v 634.755n 1.1v 639.745n 1.1v 639.755n 0.0v 644.745n 0.0v 644.755n 0.0v 649.745n 0.0v 649.755n 0.0v 654.745n 0.0v 654.755n 0.0v 659.745n 0.0v 659.755n 0.0v 664.745n 0.0v 664.755n 0.0v 669.745n 0.0v 669.755n 0.0v 674.745n 0.0v 674.755n 0.0v 679.745n 0.0v 679.755n 0.0v 684.745n 0.0v 684.755n 0.0v 689.745n 0.0v 689.755n 0.0v 694.745n 0.0v 694.755n 0.0v 699.745n 0.0v 699.755n 1.1v 704.745n 1.1v 704.755n 0.0v 709.745n 0.0v 709.755n 0.0v 714.745n 0.0v 714.755n 0.0v 719.745n 0.0v 719.755n 0.0v 724.745n 0.0v 724.755n 1.1v 729.745n 1.1v 729.755n 0.0v 734.745n 0.0v 734.755n 0.0v 739.745n 0.0v 739.755n 0.0v 744.745n 0.0v 744.755n 0.0v 749.745n 0.0v 749.755n 1.1v 754.745n 1.1v 754.755n 0.0v 759.745n 0.0v 759.755n 0.0v 764.745n 0.0v 764.755n 0.0v 769.745n 0.0v 769.755n 0.0v 774.745n 0.0v 774.755n 0.0v 779.745n 0.0v 779.755n 1.1v 784.745n 1.1v 784.755n 0.0v 789.745n 0.0v 789.755n 0.0v 794.745n 0.0v 794.755n 0.0v 799.745n 0.0v 799.755n 0.0v 804.745n 0.0v 804.755n 0.0v 809.745n 0.0v 809.755n 0.0v 814.745n 0.0v 814.755n 1.1v 819.745n 1.1v 819.755n 0.0v 824.745n 0.0v 824.755n 0.0v 829.745n 0.0v 829.755n 0.0v 834.745n 0.0v 834.755n 0.0v 839.745n 0.0v 839.755n 1.1v 844.745n 1.1v 844.755n 0.0v 849.745n 0.0v 849.755n 0.0v 854.745n 0.0v 854.755n 0.0v 859.745n 0.0v 859.755n 0.0v 864.745n 0.0v 864.755n 0.0v 869.745n 0.0v 869.755n 1.1v 874.745n 1.1v 874.755n 0.0v 879.745n 0.0v 879.755n 1.1v 884.745n 1.1v 884.755n 0.0v 889.745n 0.0v 889.755n 0.0v 894.745n 0.0v 894.755n 0.0v 899.745n 0.0v 899.755n 0.0v 904.745n 0.0v 904.755n 1.1v 909.745n 1.1v 909.755n 0.0v 914.745n 0.0v 914.755n 1.1v 919.745n 1.1v 919.755n 0.0v 924.745n 0.0v 924.755n 1.1v 929.745n 1.1v 929.755n 0.0v 934.745n 0.0v 934.755n 0.0v 939.745n 0.0v 939.755n 0.0v 944.745n 0.0v 944.755n 1.1v 949.745n 1.1v 949.755n 1.1v 954.745n 1.1v 954.755n 1.1v 959.745n 1.1v 959.755n 0.0v 964.745n 0.0v 964.755n 0.0v 969.745n 0.0v 969.755n 1.1v 974.745n 1.1v 974.755n 0.0v 979.745n 0.0v 979.755n 1.1v 984.745n 1.1v 984.755n 1.1v 989.745n 1.1v 989.755n 1.1v 994.745n 1.1v 994.755n 0.0v 999.745n 0.0v 999.755n 1.1v 1004.745n 1.1v 1004.755n 0.0v 1009.745n 0.0v 1009.755n 0.0v 1014.745n 0.0v 1014.755n 1.1v 1019.745n 1.1v 1019.755n 0.0v 1024.745n 0.0v 1024.755n 1.1v )
* (time, data): [(0, 1), (5, 0), (10, 0), (15, 0), (20, 1), (25, 1), (30, 0), (35, 0), (40, 1), (45, 1), (50, 1), (55, 1), (60, 0), (65, 0), (70, 1), (75, 1), (80, 0), (85, 1), (90, 1), (95, 0), (100, 1), (105, 1), (110, 0), (115, 0), (120, 1), (125, 1), (130, 0), (135, 0), (140, 0), (145, 1), (150, 0), (155, 0), (160, 1), (165, 1), (170, 1), (175, 1), (180, 1), (185, 1), (190, 1), (195, 1), (200, 1), (205, 1), (210, 1), (215, 1), (220, 1), (225, 0), (230, 1), (235, 1), (240, 1), (245, 1), (250, 1), (255, 1), (260, 1), (265, 0), (270, 0), (275, 1), (280, 1), (285, 1), (290, 1), (295, 1), (300, 1), (305, 1), (310, 1), (315, 1), (320, 1), (325, 1), (330, 1), (335, 1), (340, 1), (345, 1), (350, 1), (355, 0), (360, 1), (365, 1), (370, 1), (375, 1), (380, 0), (385, 1), (390, 1), (395, 1), (400, 1), (405, 1), (410, 1), (415, 1), (420, 0), (425, 1), (430, 1), (435, 1), (440, 1), (445, 1), (450, 1), (455, 1), (460, 1), (465, 1), (470, 0), (475, 0), (480, 1), (485, 1), (490, 1), (495, 0), (500, 1), (505, 1), (510, 1), (515, 1), (520, 0), (525, 0), (530, 1), (535, 0), (540, 1), (545, 1), (550, 1), (555, 1), (560, 1), (565, 1), (570, 1), (575, 1), (580, 1), (585, 1), (590, 1), (595, 1), (600, 1), (605, 1), (610, 1), (615, 1), (620, 0), (625, 1), (630, 1), (635, 1), (640, 1), (645, 0), (650, 1), (655, 1), (660, 0), (665, 0), (670, 1), (675, 0), (680, 0), (685, 1), (690, 1), (695, 1), (700, 1), (705, 1), (710, 0), (715, 0), (720, 1), (725, 1), (730, 1), (735, 1), (740, 0), (745, 1), (750, 1), (755, 1), (760, 0), (765, 1), (770, 0), (775, 1), (780, 1), (785, 0), (790, 0), (795, 0), (800, 1), (805, 1), (810, 1), (815, 1), (820, 1), (825, 1), (830, 1), (835, 1), (840, 1), (845, 0), (850, 1), (855, 1), (860, 0), (865, 0), (870, 1), (875, 0), (880, 1), (885, 1), (890, 0), (895, 1), (900, 0), (905, 1), (910, 0), (915, 1), (920, 1), (925, 1), (930, 1), (935, 1), (940, 1), (945, 1), (950, 1), (955, 1), (960, 1), (965, 1), (970, 1), (975, 0), (980, 1), (985, 1), (990, 1), (995, 0), (1000, 1), (1005, 0), (1010, 1), (1015, 1), (1020, 1), (1025, 1)]
VWEB0 WEB0 0 PWL (0n 1.1v 4.745n 1.1v 4.755n 0.0v 9.745n 0.0v 9.755n 0.0v 14.745n 0.0v 14.755n 0.0v 19.745n 0.0v 19.755n 1.1v 24.745n 1.1v 24.755n 1.1v 29.745n 1.1v 29.755n 0.0v 34.745n 0.0v 34.755n 0.0v 39.745n 0.0v 39.755n 1.1v 44.745n 1.1v 44.755n 1.1v 49.745n 1.1v 49.755n 1.1v 54.745n 1.1v 54.755n 1.1v 59.745n 1.1v 59.755n 0.0v 64.745n 0.0v 64.755n 0.0v 69.745n 0.0v 69.755n 1.1v 74.745n 1.1v 74.755n 1.1v 79.745n 1.1v 79.755n 0.0v 84.745n 0.0v 84.755n 1.1v 89.745n 1.1v 89.755n 1.1v 94.745n 1.1v 94.755n 0.0v 99.745n 0.0v 99.755n 1.1v 104.745n 1.1v 104.755n 1.1v 109.745n 1.1v 109.755n 0.0v 114.745n 0.0v 114.755n 0.0v 119.745n 0.0v 119.755n 1.1v 124.745n 1.1v 124.755n 1.1v 129.745n 1.1v 129.755n 0.0v 134.745n 0.0v 134.755n 0.0v 139.745n 0.0v 139.755n 0.0v 144.745n 0.0v 144.755n 1.1v 149.745n 1.1v 149.755n 0.0v 154.745n 0.0v 154.755n 0.0v 159.745n 0.0v 159.755n 1.1v 164.745n 1.1v 164.755n 1.1v 169.745n 1.1v 169.755n 1.1v 174.745n 1.1v 174.755n 1.1v 179.745n 1.1v 179.755n 1.1v 184.745n 1.1v 184.755n 1.1v 189.745n 1.1v 189.755n 1.1v 194.745n 1.1v 194.755n 1.1v 199.745n 1.1v 199.755n 1.1v 204.745n 1.1v 204.755n 1.1v 209.745n 1.1v 209.755n 1.1v 214.745n 1.1v 214.755n 1.1v 219.745n 1.1v 219.755n 1.1v 224.745n 1.1v 224.755n 0.0v 229.745n 0.0v 229.755n 1.1v 234.745n 1.1v 234.755n 1.1v 239.745n 1.1v 239.755n 1.1v 244.745n 1.1v 244.755n 1.1v 249.745n 1.1v 249.755n 1.1v 254.745n 1.1v 254.755n 1.1v 259.745n 1.1v 259.755n 1.1v 264.745n 1.1v 264.755n 0.0v 269.745n 0.0v 269.755n 0.0v 274.745n 0.0v 274.755n 1.1v 279.745n 1.1v 279.755n 1.1v 284.745n 1.1v 284.755n 1.1v 289.745n 1.1v 289.755n 1.1v 294.745n 1.1v 294.755n 1.1v 299.745n 1.1v 299.755n 1.1v 304.745n 1.1v 304.755n 1.1v 309.745n 1.1v 309.755n 1.1v 314.745n 1.1v 314.755n 1.1v 319.745n 1.1v 319.755n 1.1v 324.745n 1.1v 324.755n 1.1v 329.745n 1.1v 329.755n 1.1v 334.745n 1.1v 334.755n 1.1v 339.745n 1.1v 339.755n 1.1v 344.745n 1.1v 344.755n 1.1v 349.745n 1.1v 349.755n 1.1v 354.745n 1.1v 354.755n 0.0v 359.745n 0.0v 359.755n 1.1v 364.745n 1.1v 364.755n 1.1v 369.745n 1.1v 369.755n 1.1v 374.745n 1.1v 374.755n 1.1v 379.745n 1.1v 379.755n 0.0v 384.745n 0.0v 384.755n 1.1v 389.745n 1.1v 389.755n 1.1v 394.745n 1.1v 394.755n 1.1v 399.745n 1.1v 399.755n 1.1v 404.745n 1.1v 404.755n 1.1v 409.745n 1.1v 409.755n 1.1v 414.745n 1.1v 414.755n 1.1v 419.745n 1.1v 419.755n 0.0v 424.745n 0.0v 424.755n 1.1v 429.745n 1.1v 429.755n 1.1v 434.745n 1.1v 434.755n 1.1v 439.745n 1.1v 439.755n 1.1v 444.745n 1.1v 444.755n 1.1v 449.745n 1.1v 449.755n 1.1v 454.745n 1.1v 454.755n 1.1v 459.745n 1.1v 459.755n 1.1v 464.745n 1.1v 464.755n 1.1v 469.745n 1.1v 469.755n 0.0v 474.745n 0.0v 474.755n 0.0v 479.745n 0.0v 479.755n 1.1v 484.745n 1.1v 484.755n 1.1v 489.745n 1.1v 489.755n 1.1v 494.745n 1.1v 494.755n 0.0v 499.745n 0.0v 499.755n 1.1v 504.745n 1.1v 504.755n 1.1v 509.745n 1.1v 509.755n 1.1v 514.745n 1.1v 514.755n 1.1v 519.745n 1.1v 519.755n 0.0v 524.745n 0.0v 524.755n 0.0v 529.745n 0.0v 529.755n 1.1v 534.745n 1.1v 534.755n 0.0v 539.745n 0.0v 539.755n 1.1v 544.745n 1.1v 544.755n 1.1v 549.745n 1.1v 549.755n 1.1v 554.745n 1.1v 554.755n 1.1v 559.745n 1.1v 559.755n 1.1v 564.745n 1.1v 564.755n 1.1v 569.745n 1.1v 569.755n 1.1v 574.745n 1.1v 574.755n 1.1v 579.745n 1.1v 579.755n 1.1v 584.745n 1.1v 584.755n 1.1v 589.745n 1.1v 589.755n 1.1v 594.745n 1.1v 594.755n 1.1v 599.745n 1.1v 599.755n 1.1v 604.745n 1.1v 604.755n 1.1v 609.745n 1.1v 609.755n 1.1v 614.745n 1.1v 614.755n 1.1v 619.745n 1.1v 619.755n 0.0v 624.745n 0.0v 624.755n 1.1v 629.745n 1.1v 629.755n 1.1v 634.745n 1.1v 634.755n 1.1v 639.745n 1.1v 639.755n 1.1v 644.745n 1.1v 644.755n 0.0v 649.745n 0.0v 649.755n 1.1v 654.745n 1.1v 654.755n 1.1v 659.745n 1.1v 659.755n 0.0v 664.745n 0.0v 664.755n 0.0v 669.745n 0.0v 669.755n 1.1v 674.745n 1.1v 674.755n 0.0v 679.745n 0.0v 679.755n 0.0v 684.745n 0.0v 684.755n 1.1v 689.745n 1.1v 689.755n 1.1v 694.745n 1.1v 694.755n 1.1v 699.745n 1.1v 699.755n 1.1v 704.745n 1.1v 704.755n 1.1v 709.745n 1.1v 709.755n 0.0v 714.745n 0.0v 714.755n 0.0v 719.745n 0.0v 719.755n 1.1v 724.745n 1.1v 724.755n 1.1v 729.745n 1.1v 729.755n 1.1v 734.745n 1.1v 734.755n 1.1v 739.745n 1.1v 739.755n 0.0v 744.745n 0.0v 744.755n 1.1v 749.745n 1.1v 749.755n 1.1v 754.745n 1.1v 754.755n 1.1v 759.745n 1.1v 759.755n 0.0v 764.745n 0.0v 764.755n 1.1v 769.745n 1.1v 769.755n 0.0v 774.745n 0.0v 774.755n 1.1v 779.745n 1.1v 779.755n 1.1v 784.745n 1.1v 784.755n 0.0v 789.745n 0.0v 789.755n 0.0v 794.745n 0.0v 794.755n 0.0v 799.745n 0.0v 799.755n 1.1v 804.745n 1.1v 804.755n 1.1v 809.745n 1.1v 809.755n 1.1v 814.745n 1.1v 814.755n 1.1v 819.745n 1.1v 819.755n 1.1v 824.745n 1.1v 824.755n 1.1v 829.745n 1.1v 829.755n 1.1v 834.745n 1.1v 834.755n 1.1v 839.745n 1.1v 839.755n 1.1v 844.745n 1.1v 844.755n 0.0v 849.745n 0.0v 849.755n 1.1v 854.745n 1.1v 854.755n 1.1v 859.745n 1.1v 859.755n 0.0v 864.745n 0.0v 864.755n 0.0v 869.745n 0.0v 869.755n 1.1v 874.745n 1.1v 874.755n 0.0v 879.745n 0.0v 879.755n 1.1v 884.745n 1.1v 884.755n 1.1v 889.745n 1.1v 889.755n 0.0v 894.745n 0.0v 894.755n 1.1v 899.745n 1.1v 899.755n 0.0v 904.745n 0.0v 904.755n 1.1v 909.745n 1.1v 909.755n 0.0v 914.745n 0.0v 914.755n 1.1v 919.745n 1.1v 919.755n 1.1v 924.745n 1.1v 924.755n 1.1v 929.745n 1.1v 929.755n 1.1v 934.745n 1.1v 934.755n 1.1v 939.745n 1.1v 939.755n 1.1v 944.745n 1.1v 944.755n 1.1v 949.745n 1.1v 949.755n 1.1v 954.745n 1.1v 954.755n 1.1v 959.745n 1.1v 959.755n 1.1v 964.745n 1.1v 964.755n 1.1v 969.745n 1.1v 969.755n 1.1v 974.745n 1.1v 974.755n 0.0v 979.745n 0.0v 979.755n 1.1v 984.745n 1.1v 984.755n 1.1v 989.745n 1.1v 989.755n 1.1v 994.745n 1.1v 994.755n 0.0v 999.745n 0.0v 999.755n 1.1v 1004.745n 1.1v 1004.755n 0.0v 1009.745n 0.0v 1009.755n 1.1v 1014.745n 1.1v 1014.755n 1.1v 1019.745n 1.1v 1019.755n 1.1v 1024.745n 1.1v 1024.755n 1.1v )
* PULSE: period=5
Vclk0 clk0 0 PULSE (0 1.1 4.995n 0.01n 0.01n 2.49n 5n)

 * Generation of dout measurements
* CHECK dout0_0 vdout0_0ck4 = 0 time = 25
* CHECK dout0_1 vdout0_1ck4 = 0 time = 25
* CHECK dout0_2 vdout0_2ck4 = 0 time = 25
* CHECK dout0_3 vdout0_3ck4 = 1.1 time = 25
* CHECK dout0_4 vdout0_4ck4 = 0 time = 25
* CHECK dout0_5 vdout0_5ck4 = 1.1 time = 25
* CHECK dout0_6 vdout0_6ck4 = 1.1 time = 25
* CHECK dout0_7 vdout0_7ck4 = 1.1 time = 25
* CHECK dout0_8 vdout0_8ck4 = 0 time = 25
* CHECK dout0_9 vdout0_9ck4 = 1.1 time = 25
* CHECK dout0_10 vdout0_10ck4 = 0 time = 25
* CHECK dout0_11 vdout0_11ck4 = 1.1 time = 25
* CHECK dout0_12 vdout0_12ck4 = 0 time = 25
* CHECK dout0_13 vdout0_13ck4 = 0 time = 25
* CHECK dout0_14 vdout0_14ck4 = 1.1 time = 25
* CHECK dout0_15 vdout0_15ck4 = 1.1 time = 25
* CHECK dout0_16 vdout0_16ck4 = 0 time = 25
* CHECK dout0_17 vdout0_17ck4 = 1.1 time = 25
* CHECK dout0_18 vdout0_18ck4 = 1.1 time = 25
* CHECK dout0_19 vdout0_19ck4 = 0 time = 25
* CHECK dout0_20 vdout0_20ck4 = 1.1 time = 25
* CHECK dout0_21 vdout0_21ck4 = 1.1 time = 25
* CHECK dout0_22 vdout0_22ck4 = 1.1 time = 25
* CHECK dout0_23 vdout0_23ck4 = 1.1 time = 25
* CHECK dout0_24 vdout0_24ck4 = 1.1 time = 25
* CHECK dout0_25 vdout0_25ck4 = 0 time = 25
* CHECK dout0_26 vdout0_26ck4 = 0 time = 25
* CHECK dout0_27 vdout0_27ck4 = 1.1 time = 25
* CHECK dout0_28 vdout0_28ck4 = 1.1 time = 25
* CHECK dout0_29 vdout0_29ck4 = 0 time = 25
* CHECK dout0_30 vdout0_30ck4 = 1.1 time = 25
* CHECK dout0_31 vdout0_31ck4 = 1.1 time = 25
* CHECK dout0_0 vdout0_0ck5 = 0 time = 30
* CHECK dout0_1 vdout0_1ck5 = 0 time = 30
* CHECK dout0_2 vdout0_2ck5 = 0 time = 30
* CHECK dout0_3 vdout0_3ck5 = 0 time = 30
* CHECK dout0_4 vdout0_4ck5 = 0 time = 30
* CHECK dout0_5 vdout0_5ck5 = 1.1 time = 30
* CHECK dout0_6 vdout0_6ck5 = 1.1 time = 30
* CHECK dout0_7 vdout0_7ck5 = 1.1 time = 30
* CHECK dout0_8 vdout0_8ck5 = 0 time = 30
* CHECK dout0_9 vdout0_9ck5 = 1.1 time = 30
* CHECK dout0_10 vdout0_10ck5 = 1.1 time = 30
* CHECK dout0_11 vdout0_11ck5 = 1.1 time = 30
* CHECK dout0_12 vdout0_12ck5 = 0 time = 30
* CHECK dout0_13 vdout0_13ck5 = 1.1 time = 30
* CHECK dout0_14 vdout0_14ck5 = 0 time = 30
* CHECK dout0_15 vdout0_15ck5 = 1.1 time = 30
* CHECK dout0_16 vdout0_16ck5 = 1.1 time = 30
* CHECK dout0_17 vdout0_17ck5 = 1.1 time = 30
* CHECK dout0_18 vdout0_18ck5 = 0 time = 30
* CHECK dout0_19 vdout0_19ck5 = 0 time = 30
* CHECK dout0_20 vdout0_20ck5 = 1.1 time = 30
* CHECK dout0_21 vdout0_21ck5 = 1.1 time = 30
* CHECK dout0_22 vdout0_22ck5 = 1.1 time = 30
* CHECK dout0_23 vdout0_23ck5 = 1.1 time = 30
* CHECK dout0_24 vdout0_24ck5 = 1.1 time = 30
* CHECK dout0_25 vdout0_25ck5 = 0 time = 30
* CHECK dout0_26 vdout0_26ck5 = 0 time = 30
* CHECK dout0_27 vdout0_27ck5 = 0 time = 30
* CHECK dout0_28 vdout0_28ck5 = 0 time = 30
* CHECK dout0_29 vdout0_29ck5 = 0 time = 30
* CHECK dout0_30 vdout0_30ck5 = 1.1 time = 30
* CHECK dout0_31 vdout0_31ck5 = 0 time = 30
* CHECK dout0_0 vdout0_0ck9 = 1.1 time = 50
* CHECK dout0_1 vdout0_1ck9 = 1.1 time = 50
* CHECK dout0_2 vdout0_2ck9 = 1.1 time = 50
* CHECK dout0_3 vdout0_3ck9 = 0 time = 50
* CHECK dout0_4 vdout0_4ck9 = 1.1 time = 50
* CHECK dout0_5 vdout0_5ck9 = 1.1 time = 50
* CHECK dout0_6 vdout0_6ck9 = 1.1 time = 50
* CHECK dout0_7 vdout0_7ck9 = 1.1 time = 50
* CHECK dout0_8 vdout0_8ck9 = 1.1 time = 50
* CHECK dout0_9 vdout0_9ck9 = 1.1 time = 50
* CHECK dout0_10 vdout0_10ck9 = 0 time = 50
* CHECK dout0_11 vdout0_11ck9 = 1.1 time = 50
* CHECK dout0_12 vdout0_12ck9 = 0 time = 50
* CHECK dout0_13 vdout0_13ck9 = 1.1 time = 50
* CHECK dout0_14 vdout0_14ck9 = 1.1 time = 50
* CHECK dout0_15 vdout0_15ck9 = 0 time = 50
* CHECK dout0_16 vdout0_16ck9 = 1.1 time = 50
* CHECK dout0_17 vdout0_17ck9 = 1.1 time = 50
* CHECK dout0_18 vdout0_18ck9 = 1.1 time = 50
* CHECK dout0_19 vdout0_19ck9 = 0 time = 50
* CHECK dout0_20 vdout0_20ck9 = 1.1 time = 50
* CHECK dout0_21 vdout0_21ck9 = 1.1 time = 50
* CHECK dout0_22 vdout0_22ck9 = 1.1 time = 50
* CHECK dout0_23 vdout0_23ck9 = 1.1 time = 50
* CHECK dout0_24 vdout0_24ck9 = 1.1 time = 50
* CHECK dout0_25 vdout0_25ck9 = 1.1 time = 50
* CHECK dout0_26 vdout0_26ck9 = 1.1 time = 50
* CHECK dout0_27 vdout0_27ck9 = 1.1 time = 50
* CHECK dout0_28 vdout0_28ck9 = 1.1 time = 50
* CHECK dout0_29 vdout0_29ck9 = 1.1 time = 50
* CHECK dout0_30 vdout0_30ck9 = 1.1 time = 50
* CHECK dout0_31 vdout0_31ck9 = 1.1 time = 50
* CHECK dout0_0 vdout0_0ck10 = 0 time = 55
* CHECK dout0_1 vdout0_1ck10 = 0 time = 55
* CHECK dout0_2 vdout0_2ck10 = 1.1 time = 55
* CHECK dout0_3 vdout0_3ck10 = 0 time = 55
* CHECK dout0_4 vdout0_4ck10 = 0 time = 55
* CHECK dout0_5 vdout0_5ck10 = 1.1 time = 55
* CHECK dout0_6 vdout0_6ck10 = 0 time = 55
* CHECK dout0_7 vdout0_7ck10 = 1.1 time = 55
* CHECK dout0_8 vdout0_8ck10 = 0 time = 55
* CHECK dout0_9 vdout0_9ck10 = 1.1 time = 55
* CHECK dout0_10 vdout0_10ck10 = 1.1 time = 55
* CHECK dout0_11 vdout0_11ck10 = 1.1 time = 55
* CHECK dout0_12 vdout0_12ck10 = 0 time = 55
* CHECK dout0_13 vdout0_13ck10 = 0 time = 55
* CHECK dout0_14 vdout0_14ck10 = 0 time = 55
* CHECK dout0_15 vdout0_15ck10 = 1.1 time = 55
* CHECK dout0_16 vdout0_16ck10 = 1.1 time = 55
* CHECK dout0_17 vdout0_17ck10 = 1.1 time = 55
* CHECK dout0_18 vdout0_18ck10 = 1.1 time = 55
* CHECK dout0_19 vdout0_19ck10 = 0 time = 55
* CHECK dout0_20 vdout0_20ck10 = 1.1 time = 55
* CHECK dout0_21 vdout0_21ck10 = 0 time = 55
* CHECK dout0_22 vdout0_22ck10 = 0 time = 55
* CHECK dout0_23 vdout0_23ck10 = 1.1 time = 55
* CHECK dout0_24 vdout0_24ck10 = 1.1 time = 55
* CHECK dout0_25 vdout0_25ck10 = 0 time = 55
* CHECK dout0_26 vdout0_26ck10 = 0 time = 55
* CHECK dout0_27 vdout0_27ck10 = 1.1 time = 55
* CHECK dout0_28 vdout0_28ck10 = 1.1 time = 55
* CHECK dout0_29 vdout0_29ck10 = 1.1 time = 55
* CHECK dout0_30 vdout0_30ck10 = 0 time = 55
* CHECK dout0_31 vdout0_31ck10 = 1.1 time = 55
* CHECK dout0_0 vdout0_0ck11 = 1.1 time = 60
* CHECK dout0_1 vdout0_1ck11 = 1.1 time = 60
* CHECK dout0_2 vdout0_2ck11 = 0 time = 60
* CHECK dout0_3 vdout0_3ck11 = 1.1 time = 60
* CHECK dout0_4 vdout0_4ck11 = 0 time = 60
* CHECK dout0_5 vdout0_5ck11 = 1.1 time = 60
* CHECK dout0_6 vdout0_6ck11 = 0 time = 60
* CHECK dout0_7 vdout0_7ck11 = 0 time = 60
* CHECK dout0_8 vdout0_8ck11 = 1.1 time = 60
* CHECK dout0_9 vdout0_9ck11 = 0 time = 60
* CHECK dout0_10 vdout0_10ck11 = 0 time = 60
* CHECK dout0_11 vdout0_11ck11 = 0 time = 60
* CHECK dout0_12 vdout0_12ck11 = 1.1 time = 60
* CHECK dout0_13 vdout0_13ck11 = 1.1 time = 60
* CHECK dout0_14 vdout0_14ck11 = 1.1 time = 60
* CHECK dout0_15 vdout0_15ck11 = 0 time = 60
* CHECK dout0_16 vdout0_16ck11 = 1.1 time = 60
* CHECK dout0_17 vdout0_17ck11 = 1.1 time = 60
* CHECK dout0_18 vdout0_18ck11 = 0 time = 60
* CHECK dout0_19 vdout0_19ck11 = 1.1 time = 60
* CHECK dout0_20 vdout0_20ck11 = 0 time = 60
* CHECK dout0_21 vdout0_21ck11 = 1.1 time = 60
* CHECK dout0_22 vdout0_22ck11 = 1.1 time = 60
* CHECK dout0_23 vdout0_23ck11 = 0 time = 60
* CHECK dout0_24 vdout0_24ck11 = 1.1 time = 60
* CHECK dout0_25 vdout0_25ck11 = 1.1 time = 60
* CHECK dout0_26 vdout0_26ck11 = 1.1 time = 60
* CHECK dout0_27 vdout0_27ck11 = 0 time = 60
* CHECK dout0_28 vdout0_28ck11 = 0 time = 60
* CHECK dout0_29 vdout0_29ck11 = 0 time = 60
* CHECK dout0_30 vdout0_30ck11 = 1.1 time = 60
* CHECK dout0_31 vdout0_31ck11 = 1.1 time = 60
* CHECK dout0_0 vdout0_0ck18 = 0 time = 95
* CHECK dout0_1 vdout0_1ck18 = 0 time = 95
* CHECK dout0_2 vdout0_2ck18 = 1.1 time = 95
* CHECK dout0_3 vdout0_3ck18 = 0 time = 95
* CHECK dout0_4 vdout0_4ck18 = 0 time = 95
* CHECK dout0_5 vdout0_5ck18 = 1.1 time = 95
* CHECK dout0_6 vdout0_6ck18 = 0 time = 95
* CHECK dout0_7 vdout0_7ck18 = 1.1 time = 95
* CHECK dout0_8 vdout0_8ck18 = 0 time = 95
* CHECK dout0_9 vdout0_9ck18 = 1.1 time = 95
* CHECK dout0_10 vdout0_10ck18 = 1.1 time = 95
* CHECK dout0_11 vdout0_11ck18 = 1.1 time = 95
* CHECK dout0_12 vdout0_12ck18 = 0 time = 95
* CHECK dout0_13 vdout0_13ck18 = 0 time = 95
* CHECK dout0_14 vdout0_14ck18 = 0 time = 95
* CHECK dout0_15 vdout0_15ck18 = 1.1 time = 95
* CHECK dout0_16 vdout0_16ck18 = 1.1 time = 95
* CHECK dout0_17 vdout0_17ck18 = 1.1 time = 95
* CHECK dout0_18 vdout0_18ck18 = 1.1 time = 95
* CHECK dout0_19 vdout0_19ck18 = 0 time = 95
* CHECK dout0_20 vdout0_20ck18 = 1.1 time = 95
* CHECK dout0_21 vdout0_21ck18 = 0 time = 95
* CHECK dout0_22 vdout0_22ck18 = 0 time = 95
* CHECK dout0_23 vdout0_23ck18 = 1.1 time = 95
* CHECK dout0_24 vdout0_24ck18 = 1.1 time = 95
* CHECK dout0_25 vdout0_25ck18 = 0 time = 95
* CHECK dout0_26 vdout0_26ck18 = 0 time = 95
* CHECK dout0_27 vdout0_27ck18 = 1.1 time = 95
* CHECK dout0_28 vdout0_28ck18 = 1.1 time = 95
* CHECK dout0_29 vdout0_29ck18 = 1.1 time = 95
* CHECK dout0_30 vdout0_30ck18 = 0 time = 95
* CHECK dout0_31 vdout0_31ck18 = 1.1 time = 95
* CHECK dout0_0 vdout0_0ck20 = 0 time = 105
* CHECK dout0_1 vdout0_1ck20 = 0 time = 105
* CHECK dout0_2 vdout0_2ck20 = 0 time = 105
* CHECK dout0_3 vdout0_3ck20 = 1.1 time = 105
* CHECK dout0_4 vdout0_4ck20 = 1.1 time = 105
* CHECK dout0_5 vdout0_5ck20 = 1.1 time = 105
* CHECK dout0_6 vdout0_6ck20 = 1.1 time = 105
* CHECK dout0_7 vdout0_7ck20 = 0 time = 105
* CHECK dout0_8 vdout0_8ck20 = 1.1 time = 105
* CHECK dout0_9 vdout0_9ck20 = 0 time = 105
* CHECK dout0_10 vdout0_10ck20 = 0 time = 105
* CHECK dout0_11 vdout0_11ck20 = 1.1 time = 105
* CHECK dout0_12 vdout0_12ck20 = 1.1 time = 105
* CHECK dout0_13 vdout0_13ck20 = 1.1 time = 105
* CHECK dout0_14 vdout0_14ck20 = 0 time = 105
* CHECK dout0_15 vdout0_15ck20 = 0 time = 105
* CHECK dout0_16 vdout0_16ck20 = 1.1 time = 105
* CHECK dout0_17 vdout0_17ck20 = 0 time = 105
* CHECK dout0_18 vdout0_18ck20 = 1.1 time = 105
* CHECK dout0_19 vdout0_19ck20 = 1.1 time = 105
* CHECK dout0_20 vdout0_20ck20 = 0 time = 105
* CHECK dout0_21 vdout0_21ck20 = 0 time = 105
* CHECK dout0_22 vdout0_22ck20 = 1.1 time = 105
* CHECK dout0_23 vdout0_23ck20 = 1.1 time = 105
* CHECK dout0_24 vdout0_24ck20 = 0 time = 105
* CHECK dout0_25 vdout0_25ck20 = 1.1 time = 105
* CHECK dout0_26 vdout0_26ck20 = 1.1 time = 105
* CHECK dout0_27 vdout0_27ck20 = 0 time = 105
* CHECK dout0_28 vdout0_28ck20 = 0 time = 105
* CHECK dout0_29 vdout0_29ck20 = 0 time = 105
* CHECK dout0_30 vdout0_30ck20 = 0 time = 105
* CHECK dout0_31 vdout0_31ck20 = 1.1 time = 105
* CHECK dout0_0 vdout0_0ck24 = 1.1 time = 125
* CHECK dout0_1 vdout0_1ck24 = 1.1 time = 125
* CHECK dout0_2 vdout0_2ck24 = 0 time = 125
* CHECK dout0_3 vdout0_3ck24 = 1.1 time = 125
* CHECK dout0_4 vdout0_4ck24 = 1.1 time = 125
* CHECK dout0_5 vdout0_5ck24 = 1.1 time = 125
* CHECK dout0_6 vdout0_6ck24 = 0 time = 125
* CHECK dout0_7 vdout0_7ck24 = 1.1 time = 125
* CHECK dout0_8 vdout0_8ck24 = 1.1 time = 125
* CHECK dout0_9 vdout0_9ck24 = 0 time = 125
* CHECK dout0_10 vdout0_10ck24 = 1.1 time = 125
* CHECK dout0_11 vdout0_11ck24 = 1.1 time = 125
* CHECK dout0_12 vdout0_12ck24 = 0 time = 125
* CHECK dout0_13 vdout0_13ck24 = 1.1 time = 125
* CHECK dout0_14 vdout0_14ck24 = 0 time = 125
* CHECK dout0_15 vdout0_15ck24 = 0 time = 125
* CHECK dout0_16 vdout0_16ck24 = 1.1 time = 125
* CHECK dout0_17 vdout0_17ck24 = 0 time = 125
* CHECK dout0_18 vdout0_18ck24 = 1.1 time = 125
* CHECK dout0_19 vdout0_19ck24 = 1.1 time = 125
* CHECK dout0_20 vdout0_20ck24 = 0 time = 125
* CHECK dout0_21 vdout0_21ck24 = 1.1 time = 125
* CHECK dout0_22 vdout0_22ck24 = 1.1 time = 125
* CHECK dout0_23 vdout0_23ck24 = 1.1 time = 125
* CHECK dout0_24 vdout0_24ck24 = 0 time = 125
* CHECK dout0_25 vdout0_25ck24 = 1.1 time = 125
* CHECK dout0_26 vdout0_26ck24 = 0 time = 125
* CHECK dout0_27 vdout0_27ck24 = 1.1 time = 125
* CHECK dout0_28 vdout0_28ck24 = 0 time = 125
* CHECK dout0_29 vdout0_29ck24 = 1.1 time = 125
* CHECK dout0_30 vdout0_30ck24 = 1.1 time = 125
* CHECK dout0_31 vdout0_31ck24 = 0 time = 125
* CHECK dout0_0 vdout0_0ck25 = 1.1 time = 130
* CHECK dout0_1 vdout0_1ck25 = 1.1 time = 130
* CHECK dout0_2 vdout0_2ck25 = 0 time = 130
* CHECK dout0_3 vdout0_3ck25 = 1.1 time = 130
* CHECK dout0_4 vdout0_4ck25 = 1.1 time = 130
* CHECK dout0_5 vdout0_5ck25 = 1.1 time = 130
* CHECK dout0_6 vdout0_6ck25 = 0 time = 130
* CHECK dout0_7 vdout0_7ck25 = 1.1 time = 130
* CHECK dout0_8 vdout0_8ck25 = 1.1 time = 130
* CHECK dout0_9 vdout0_9ck25 = 0 time = 130
* CHECK dout0_10 vdout0_10ck25 = 1.1 time = 130
* CHECK dout0_11 vdout0_11ck25 = 1.1 time = 130
* CHECK dout0_12 vdout0_12ck25 = 0 time = 130
* CHECK dout0_13 vdout0_13ck25 = 1.1 time = 130
* CHECK dout0_14 vdout0_14ck25 = 0 time = 130
* CHECK dout0_15 vdout0_15ck25 = 0 time = 130
* CHECK dout0_16 vdout0_16ck25 = 1.1 time = 130
* CHECK dout0_17 vdout0_17ck25 = 0 time = 130
* CHECK dout0_18 vdout0_18ck25 = 1.1 time = 130
* CHECK dout0_19 vdout0_19ck25 = 1.1 time = 130
* CHECK dout0_20 vdout0_20ck25 = 0 time = 130
* CHECK dout0_21 vdout0_21ck25 = 1.1 time = 130
* CHECK dout0_22 vdout0_22ck25 = 1.1 time = 130
* CHECK dout0_23 vdout0_23ck25 = 1.1 time = 130
* CHECK dout0_24 vdout0_24ck25 = 0 time = 130
* CHECK dout0_25 vdout0_25ck25 = 1.1 time = 130
* CHECK dout0_26 vdout0_26ck25 = 0 time = 130
* CHECK dout0_27 vdout0_27ck25 = 1.1 time = 130
* CHECK dout0_28 vdout0_28ck25 = 0 time = 130
* CHECK dout0_29 vdout0_29ck25 = 1.1 time = 130
* CHECK dout0_30 vdout0_30ck25 = 1.1 time = 130
* CHECK dout0_31 vdout0_31ck25 = 0 time = 130
* CHECK dout0_0 vdout0_0ck29 = 1.1 time = 150
* CHECK dout0_1 vdout0_1ck29 = 1.1 time = 150
* CHECK dout0_2 vdout0_2ck29 = 1.1 time = 150
* CHECK dout0_3 vdout0_3ck29 = 0 time = 150
* CHECK dout0_4 vdout0_4ck29 = 0 time = 150
* CHECK dout0_5 vdout0_5ck29 = 1.1 time = 150
* CHECK dout0_6 vdout0_6ck29 = 0 time = 150
* CHECK dout0_7 vdout0_7ck29 = 0 time = 150
* CHECK dout0_8 vdout0_8ck29 = 1.1 time = 150
* CHECK dout0_9 vdout0_9ck29 = 1.1 time = 150
* CHECK dout0_10 vdout0_10ck29 = 1.1 time = 150
* CHECK dout0_11 vdout0_11ck29 = 1.1 time = 150
* CHECK dout0_12 vdout0_12ck29 = 0 time = 150
* CHECK dout0_13 vdout0_13ck29 = 1.1 time = 150
* CHECK dout0_14 vdout0_14ck29 = 1.1 time = 150
* CHECK dout0_15 vdout0_15ck29 = 1.1 time = 150
* CHECK dout0_16 vdout0_16ck29 = 1.1 time = 150
* CHECK dout0_17 vdout0_17ck29 = 1.1 time = 150
* CHECK dout0_18 vdout0_18ck29 = 0 time = 150
* CHECK dout0_19 vdout0_19ck29 = 1.1 time = 150
* CHECK dout0_20 vdout0_20ck29 = 1.1 time = 150
* CHECK dout0_21 vdout0_21ck29 = 0 time = 150
* CHECK dout0_22 vdout0_22ck29 = 1.1 time = 150
* CHECK dout0_23 vdout0_23ck29 = 1.1 time = 150
* CHECK dout0_24 vdout0_24ck29 = 0 time = 150
* CHECK dout0_25 vdout0_25ck29 = 1.1 time = 150
* CHECK dout0_26 vdout0_26ck29 = 1.1 time = 150
* CHECK dout0_27 vdout0_27ck29 = 0 time = 150
* CHECK dout0_28 vdout0_28ck29 = 1.1 time = 150
* CHECK dout0_29 vdout0_29ck29 = 1.1 time = 150
* CHECK dout0_30 vdout0_30ck29 = 0 time = 150
* CHECK dout0_31 vdout0_31ck29 = 0 time = 150
* CHECK dout0_0 vdout0_0ck32 = 1.1 time = 165
* CHECK dout0_1 vdout0_1ck32 = 1.1 time = 165
* CHECK dout0_2 vdout0_2ck32 = 1.1 time = 165
* CHECK dout0_3 vdout0_3ck32 = 1.1 time = 165
* CHECK dout0_4 vdout0_4ck32 = 0 time = 165
* CHECK dout0_5 vdout0_5ck32 = 1.1 time = 165
* CHECK dout0_6 vdout0_6ck32 = 1.1 time = 165
* CHECK dout0_7 vdout0_7ck32 = 0 time = 165
* CHECK dout0_8 vdout0_8ck32 = 0 time = 165
* CHECK dout0_9 vdout0_9ck32 = 1.1 time = 165
* CHECK dout0_10 vdout0_10ck32 = 0 time = 165
* CHECK dout0_11 vdout0_11ck32 = 1.1 time = 165
* CHECK dout0_12 vdout0_12ck32 = 1.1 time = 165
* CHECK dout0_13 vdout0_13ck32 = 1.1 time = 165
* CHECK dout0_14 vdout0_14ck32 = 0 time = 165
* CHECK dout0_15 vdout0_15ck32 = 1.1 time = 165
* CHECK dout0_16 vdout0_16ck32 = 1.1 time = 165
* CHECK dout0_17 vdout0_17ck32 = 0 time = 165
* CHECK dout0_18 vdout0_18ck32 = 1.1 time = 165
* CHECK dout0_19 vdout0_19ck32 = 0 time = 165
* CHECK dout0_20 vdout0_20ck32 = 0 time = 165
* CHECK dout0_21 vdout0_21ck32 = 0 time = 165
* CHECK dout0_22 vdout0_22ck32 = 0 time = 165
* CHECK dout0_23 vdout0_23ck32 = 0 time = 165
* CHECK dout0_24 vdout0_24ck32 = 1.1 time = 165
* CHECK dout0_25 vdout0_25ck32 = 1.1 time = 165
* CHECK dout0_26 vdout0_26ck32 = 1.1 time = 165
* CHECK dout0_27 vdout0_27ck32 = 0 time = 165
* CHECK dout0_28 vdout0_28ck32 = 0 time = 165
* CHECK dout0_29 vdout0_29ck32 = 0 time = 165
* CHECK dout0_30 vdout0_30ck32 = 0 time = 165
* CHECK dout0_31 vdout0_31ck32 = 1.1 time = 165
* CHECK dout0_0 vdout0_0ck33 = 0 time = 170
* CHECK dout0_1 vdout0_1ck33 = 0 time = 170
* CHECK dout0_2 vdout0_2ck33 = 0 time = 170
* CHECK dout0_3 vdout0_3ck33 = 1.1 time = 170
* CHECK dout0_4 vdout0_4ck33 = 1.1 time = 170
* CHECK dout0_5 vdout0_5ck33 = 0 time = 170
* CHECK dout0_6 vdout0_6ck33 = 0 time = 170
* CHECK dout0_7 vdout0_7ck33 = 0 time = 170
* CHECK dout0_8 vdout0_8ck33 = 1.1 time = 170
* CHECK dout0_9 vdout0_9ck33 = 1.1 time = 170
* CHECK dout0_10 vdout0_10ck33 = 0 time = 170
* CHECK dout0_11 vdout0_11ck33 = 0 time = 170
* CHECK dout0_12 vdout0_12ck33 = 0 time = 170
* CHECK dout0_13 vdout0_13ck33 = 0 time = 170
* CHECK dout0_14 vdout0_14ck33 = 1.1 time = 170
* CHECK dout0_15 vdout0_15ck33 = 1.1 time = 170
* CHECK dout0_16 vdout0_16ck33 = 0 time = 170
* CHECK dout0_17 vdout0_17ck33 = 0 time = 170
* CHECK dout0_18 vdout0_18ck33 = 0 time = 170
* CHECK dout0_19 vdout0_19ck33 = 1.1 time = 170
* CHECK dout0_20 vdout0_20ck33 = 0 time = 170
* CHECK dout0_21 vdout0_21ck33 = 0 time = 170
* CHECK dout0_22 vdout0_22ck33 = 0 time = 170
* CHECK dout0_23 vdout0_23ck33 = 0 time = 170
* CHECK dout0_24 vdout0_24ck33 = 1.1 time = 170
* CHECK dout0_25 vdout0_25ck33 = 0 time = 170
* CHECK dout0_26 vdout0_26ck33 = 0 time = 170
* CHECK dout0_27 vdout0_27ck33 = 0 time = 170
* CHECK dout0_28 vdout0_28ck33 = 0 time = 170
* CHECK dout0_29 vdout0_29ck33 = 1.1 time = 170
* CHECK dout0_30 vdout0_30ck33 = 0 time = 170
* CHECK dout0_31 vdout0_31ck33 = 0 time = 170
* CHECK dout0_0 vdout0_0ck34 = 0 time = 175
* CHECK dout0_1 vdout0_1ck34 = 0 time = 175
* CHECK dout0_2 vdout0_2ck34 = 0 time = 175
* CHECK dout0_3 vdout0_3ck34 = 1.1 time = 175
* CHECK dout0_4 vdout0_4ck34 = 1.1 time = 175
* CHECK dout0_5 vdout0_5ck34 = 0 time = 175
* CHECK dout0_6 vdout0_6ck34 = 0 time = 175
* CHECK dout0_7 vdout0_7ck34 = 0 time = 175
* CHECK dout0_8 vdout0_8ck34 = 1.1 time = 175
* CHECK dout0_9 vdout0_9ck34 = 1.1 time = 175
* CHECK dout0_10 vdout0_10ck34 = 0 time = 175
* CHECK dout0_11 vdout0_11ck34 = 0 time = 175
* CHECK dout0_12 vdout0_12ck34 = 0 time = 175
* CHECK dout0_13 vdout0_13ck34 = 0 time = 175
* CHECK dout0_14 vdout0_14ck34 = 1.1 time = 175
* CHECK dout0_15 vdout0_15ck34 = 1.1 time = 175
* CHECK dout0_16 vdout0_16ck34 = 0 time = 175
* CHECK dout0_17 vdout0_17ck34 = 0 time = 175
* CHECK dout0_18 vdout0_18ck34 = 0 time = 175
* CHECK dout0_19 vdout0_19ck34 = 1.1 time = 175
* CHECK dout0_20 vdout0_20ck34 = 0 time = 175
* CHECK dout0_21 vdout0_21ck34 = 0 time = 175
* CHECK dout0_22 vdout0_22ck34 = 0 time = 175
* CHECK dout0_23 vdout0_23ck34 = 0 time = 175
* CHECK dout0_24 vdout0_24ck34 = 1.1 time = 175
* CHECK dout0_25 vdout0_25ck34 = 0 time = 175
* CHECK dout0_26 vdout0_26ck34 = 0 time = 175
* CHECK dout0_27 vdout0_27ck34 = 0 time = 175
* CHECK dout0_28 vdout0_28ck34 = 0 time = 175
* CHECK dout0_29 vdout0_29ck34 = 1.1 time = 175
* CHECK dout0_30 vdout0_30ck34 = 0 time = 175
* CHECK dout0_31 vdout0_31ck34 = 0 time = 175
* CHECK dout0_0 vdout0_0ck35 = 0 time = 180
* CHECK dout0_1 vdout0_1ck35 = 0 time = 180
* CHECK dout0_2 vdout0_2ck35 = 0 time = 180
* CHECK dout0_3 vdout0_3ck35 = 1.1 time = 180
* CHECK dout0_4 vdout0_4ck35 = 1.1 time = 180
* CHECK dout0_5 vdout0_5ck35 = 0 time = 180
* CHECK dout0_6 vdout0_6ck35 = 0 time = 180
* CHECK dout0_7 vdout0_7ck35 = 0 time = 180
* CHECK dout0_8 vdout0_8ck35 = 1.1 time = 180
* CHECK dout0_9 vdout0_9ck35 = 1.1 time = 180
* CHECK dout0_10 vdout0_10ck35 = 0 time = 180
* CHECK dout0_11 vdout0_11ck35 = 0 time = 180
* CHECK dout0_12 vdout0_12ck35 = 0 time = 180
* CHECK dout0_13 vdout0_13ck35 = 0 time = 180
* CHECK dout0_14 vdout0_14ck35 = 1.1 time = 180
* CHECK dout0_15 vdout0_15ck35 = 1.1 time = 180
* CHECK dout0_16 vdout0_16ck35 = 0 time = 180
* CHECK dout0_17 vdout0_17ck35 = 0 time = 180
* CHECK dout0_18 vdout0_18ck35 = 0 time = 180
* CHECK dout0_19 vdout0_19ck35 = 1.1 time = 180
* CHECK dout0_20 vdout0_20ck35 = 0 time = 180
* CHECK dout0_21 vdout0_21ck35 = 0 time = 180
* CHECK dout0_22 vdout0_22ck35 = 0 time = 180
* CHECK dout0_23 vdout0_23ck35 = 0 time = 180
* CHECK dout0_24 vdout0_24ck35 = 1.1 time = 180
* CHECK dout0_25 vdout0_25ck35 = 0 time = 180
* CHECK dout0_26 vdout0_26ck35 = 0 time = 180
* CHECK dout0_27 vdout0_27ck35 = 0 time = 180
* CHECK dout0_28 vdout0_28ck35 = 0 time = 180
* CHECK dout0_29 vdout0_29ck35 = 1.1 time = 180
* CHECK dout0_30 vdout0_30ck35 = 0 time = 180
* CHECK dout0_31 vdout0_31ck35 = 0 time = 180
* CHECK dout0_0 vdout0_0ck36 = 0 time = 185
* CHECK dout0_1 vdout0_1ck36 = 0 time = 185
* CHECK dout0_2 vdout0_2ck36 = 0 time = 185
* CHECK dout0_3 vdout0_3ck36 = 1.1 time = 185
* CHECK dout0_4 vdout0_4ck36 = 1.1 time = 185
* CHECK dout0_5 vdout0_5ck36 = 0 time = 185
* CHECK dout0_6 vdout0_6ck36 = 0 time = 185
* CHECK dout0_7 vdout0_7ck36 = 0 time = 185
* CHECK dout0_8 vdout0_8ck36 = 1.1 time = 185
* CHECK dout0_9 vdout0_9ck36 = 1.1 time = 185
* CHECK dout0_10 vdout0_10ck36 = 0 time = 185
* CHECK dout0_11 vdout0_11ck36 = 0 time = 185
* CHECK dout0_12 vdout0_12ck36 = 0 time = 185
* CHECK dout0_13 vdout0_13ck36 = 0 time = 185
* CHECK dout0_14 vdout0_14ck36 = 1.1 time = 185
* CHECK dout0_15 vdout0_15ck36 = 1.1 time = 185
* CHECK dout0_16 vdout0_16ck36 = 0 time = 185
* CHECK dout0_17 vdout0_17ck36 = 0 time = 185
* CHECK dout0_18 vdout0_18ck36 = 0 time = 185
* CHECK dout0_19 vdout0_19ck36 = 1.1 time = 185
* CHECK dout0_20 vdout0_20ck36 = 0 time = 185
* CHECK dout0_21 vdout0_21ck36 = 0 time = 185
* CHECK dout0_22 vdout0_22ck36 = 0 time = 185
* CHECK dout0_23 vdout0_23ck36 = 0 time = 185
* CHECK dout0_24 vdout0_24ck36 = 1.1 time = 185
* CHECK dout0_25 vdout0_25ck36 = 0 time = 185
* CHECK dout0_26 vdout0_26ck36 = 0 time = 185
* CHECK dout0_27 vdout0_27ck36 = 0 time = 185
* CHECK dout0_28 vdout0_28ck36 = 0 time = 185
* CHECK dout0_29 vdout0_29ck36 = 1.1 time = 185
* CHECK dout0_30 vdout0_30ck36 = 0 time = 185
* CHECK dout0_31 vdout0_31ck36 = 0 time = 185
* CHECK dout0_0 vdout0_0ck37 = 1.1 time = 190
* CHECK dout0_1 vdout0_1ck37 = 1.1 time = 190
* CHECK dout0_2 vdout0_2ck37 = 1.1 time = 190
* CHECK dout0_3 vdout0_3ck37 = 0 time = 190
* CHECK dout0_4 vdout0_4ck37 = 1.1 time = 190
* CHECK dout0_5 vdout0_5ck37 = 1.1 time = 190
* CHECK dout0_6 vdout0_6ck37 = 1.1 time = 190
* CHECK dout0_7 vdout0_7ck37 = 1.1 time = 190
* CHECK dout0_8 vdout0_8ck37 = 1.1 time = 190
* CHECK dout0_9 vdout0_9ck37 = 1.1 time = 190
* CHECK dout0_10 vdout0_10ck37 = 0 time = 190
* CHECK dout0_11 vdout0_11ck37 = 1.1 time = 190
* CHECK dout0_12 vdout0_12ck37 = 0 time = 190
* CHECK dout0_13 vdout0_13ck37 = 1.1 time = 190
* CHECK dout0_14 vdout0_14ck37 = 1.1 time = 190
* CHECK dout0_15 vdout0_15ck37 = 0 time = 190
* CHECK dout0_16 vdout0_16ck37 = 1.1 time = 190
* CHECK dout0_17 vdout0_17ck37 = 1.1 time = 190
* CHECK dout0_18 vdout0_18ck37 = 1.1 time = 190
* CHECK dout0_19 vdout0_19ck37 = 0 time = 190
* CHECK dout0_20 vdout0_20ck37 = 1.1 time = 190
* CHECK dout0_21 vdout0_21ck37 = 1.1 time = 190
* CHECK dout0_22 vdout0_22ck37 = 1.1 time = 190
* CHECK dout0_23 vdout0_23ck37 = 1.1 time = 190
* CHECK dout0_24 vdout0_24ck37 = 1.1 time = 190
* CHECK dout0_25 vdout0_25ck37 = 1.1 time = 190
* CHECK dout0_26 vdout0_26ck37 = 1.1 time = 190
* CHECK dout0_27 vdout0_27ck37 = 1.1 time = 190
* CHECK dout0_28 vdout0_28ck37 = 1.1 time = 190
* CHECK dout0_29 vdout0_29ck37 = 1.1 time = 190
* CHECK dout0_30 vdout0_30ck37 = 1.1 time = 190
* CHECK dout0_31 vdout0_31ck37 = 1.1 time = 190
* CHECK dout0_0 vdout0_0ck38 = 0 time = 195
* CHECK dout0_1 vdout0_1ck38 = 0 time = 195
* CHECK dout0_2 vdout0_2ck38 = 0 time = 195
* CHECK dout0_3 vdout0_3ck38 = 1.1 time = 195
* CHECK dout0_4 vdout0_4ck38 = 1.1 time = 195
* CHECK dout0_5 vdout0_5ck38 = 0 time = 195
* CHECK dout0_6 vdout0_6ck38 = 0 time = 195
* CHECK dout0_7 vdout0_7ck38 = 0 time = 195
* CHECK dout0_8 vdout0_8ck38 = 1.1 time = 195
* CHECK dout0_9 vdout0_9ck38 = 1.1 time = 195
* CHECK dout0_10 vdout0_10ck38 = 0 time = 195
* CHECK dout0_11 vdout0_11ck38 = 0 time = 195
* CHECK dout0_12 vdout0_12ck38 = 0 time = 195
* CHECK dout0_13 vdout0_13ck38 = 0 time = 195
* CHECK dout0_14 vdout0_14ck38 = 1.1 time = 195
* CHECK dout0_15 vdout0_15ck38 = 1.1 time = 195
* CHECK dout0_16 vdout0_16ck38 = 0 time = 195
* CHECK dout0_17 vdout0_17ck38 = 0 time = 195
* CHECK dout0_18 vdout0_18ck38 = 0 time = 195
* CHECK dout0_19 vdout0_19ck38 = 1.1 time = 195
* CHECK dout0_20 vdout0_20ck38 = 0 time = 195
* CHECK dout0_21 vdout0_21ck38 = 0 time = 195
* CHECK dout0_22 vdout0_22ck38 = 0 time = 195
* CHECK dout0_23 vdout0_23ck38 = 0 time = 195
* CHECK dout0_24 vdout0_24ck38 = 1.1 time = 195
* CHECK dout0_25 vdout0_25ck38 = 0 time = 195
* CHECK dout0_26 vdout0_26ck38 = 0 time = 195
* CHECK dout0_27 vdout0_27ck38 = 0 time = 195
* CHECK dout0_28 vdout0_28ck38 = 0 time = 195
* CHECK dout0_29 vdout0_29ck38 = 1.1 time = 195
* CHECK dout0_30 vdout0_30ck38 = 0 time = 195
* CHECK dout0_31 vdout0_31ck38 = 0 time = 195
* CHECK dout0_0 vdout0_0ck39 = 1.1 time = 200
* CHECK dout0_1 vdout0_1ck39 = 1.1 time = 200
* CHECK dout0_2 vdout0_2ck39 = 1.1 time = 200
* CHECK dout0_3 vdout0_3ck39 = 0 time = 200
* CHECK dout0_4 vdout0_4ck39 = 1.1 time = 200
* CHECK dout0_5 vdout0_5ck39 = 1.1 time = 200
* CHECK dout0_6 vdout0_6ck39 = 1.1 time = 200
* CHECK dout0_7 vdout0_7ck39 = 1.1 time = 200
* CHECK dout0_8 vdout0_8ck39 = 1.1 time = 200
* CHECK dout0_9 vdout0_9ck39 = 1.1 time = 200
* CHECK dout0_10 vdout0_10ck39 = 0 time = 200
* CHECK dout0_11 vdout0_11ck39 = 1.1 time = 200
* CHECK dout0_12 vdout0_12ck39 = 0 time = 200
* CHECK dout0_13 vdout0_13ck39 = 1.1 time = 200
* CHECK dout0_14 vdout0_14ck39 = 1.1 time = 200
* CHECK dout0_15 vdout0_15ck39 = 0 time = 200
* CHECK dout0_16 vdout0_16ck39 = 1.1 time = 200
* CHECK dout0_17 vdout0_17ck39 = 1.1 time = 200
* CHECK dout0_18 vdout0_18ck39 = 1.1 time = 200
* CHECK dout0_19 vdout0_19ck39 = 0 time = 200
* CHECK dout0_20 vdout0_20ck39 = 1.1 time = 200
* CHECK dout0_21 vdout0_21ck39 = 1.1 time = 200
* CHECK dout0_22 vdout0_22ck39 = 1.1 time = 200
* CHECK dout0_23 vdout0_23ck39 = 1.1 time = 200
* CHECK dout0_24 vdout0_24ck39 = 1.1 time = 200
* CHECK dout0_25 vdout0_25ck39 = 1.1 time = 200
* CHECK dout0_26 vdout0_26ck39 = 1.1 time = 200
* CHECK dout0_27 vdout0_27ck39 = 1.1 time = 200
* CHECK dout0_28 vdout0_28ck39 = 1.1 time = 200
* CHECK dout0_29 vdout0_29ck39 = 1.1 time = 200
* CHECK dout0_30 vdout0_30ck39 = 1.1 time = 200
* CHECK dout0_31 vdout0_31ck39 = 1.1 time = 200
* CHECK dout0_0 vdout0_0ck40 = 0 time = 205
* CHECK dout0_1 vdout0_1ck40 = 1.1 time = 205
* CHECK dout0_2 vdout0_2ck40 = 1.1 time = 205
* CHECK dout0_3 vdout0_3ck40 = 1.1 time = 205
* CHECK dout0_4 vdout0_4ck40 = 1.1 time = 205
* CHECK dout0_5 vdout0_5ck40 = 1.1 time = 205
* CHECK dout0_6 vdout0_6ck40 = 0 time = 205
* CHECK dout0_7 vdout0_7ck40 = 1.1 time = 205
* CHECK dout0_8 vdout0_8ck40 = 0 time = 205
* CHECK dout0_9 vdout0_9ck40 = 1.1 time = 205
* CHECK dout0_10 vdout0_10ck40 = 0 time = 205
* CHECK dout0_11 vdout0_11ck40 = 1.1 time = 205
* CHECK dout0_12 vdout0_12ck40 = 0 time = 205
* CHECK dout0_13 vdout0_13ck40 = 1.1 time = 205
* CHECK dout0_14 vdout0_14ck40 = 0 time = 205
* CHECK dout0_15 vdout0_15ck40 = 1.1 time = 205
* CHECK dout0_16 vdout0_16ck40 = 0 time = 205
* CHECK dout0_17 vdout0_17ck40 = 1.1 time = 205
* CHECK dout0_18 vdout0_18ck40 = 1.1 time = 205
* CHECK dout0_19 vdout0_19ck40 = 1.1 time = 205
* CHECK dout0_20 vdout0_20ck40 = 0 time = 205
* CHECK dout0_21 vdout0_21ck40 = 0 time = 205
* CHECK dout0_22 vdout0_22ck40 = 1.1 time = 205
* CHECK dout0_23 vdout0_23ck40 = 0 time = 205
* CHECK dout0_24 vdout0_24ck40 = 0 time = 205
* CHECK dout0_25 vdout0_25ck40 = 0 time = 205
* CHECK dout0_26 vdout0_26ck40 = 0 time = 205
* CHECK dout0_27 vdout0_27ck40 = 0 time = 205
* CHECK dout0_28 vdout0_28ck40 = 0 time = 205
* CHECK dout0_29 vdout0_29ck40 = 0 time = 205
* CHECK dout0_30 vdout0_30ck40 = 1.1 time = 205
* CHECK dout0_31 vdout0_31ck40 = 0 time = 205
* CHECK dout0_0 vdout0_0ck41 = 1.1 time = 210
* CHECK dout0_1 vdout0_1ck41 = 1.1 time = 210
* CHECK dout0_2 vdout0_2ck41 = 1.1 time = 210
* CHECK dout0_3 vdout0_3ck41 = 1.1 time = 210
* CHECK dout0_4 vdout0_4ck41 = 0 time = 210
* CHECK dout0_5 vdout0_5ck41 = 1.1 time = 210
* CHECK dout0_6 vdout0_6ck41 = 1.1 time = 210
* CHECK dout0_7 vdout0_7ck41 = 0 time = 210
* CHECK dout0_8 vdout0_8ck41 = 0 time = 210
* CHECK dout0_9 vdout0_9ck41 = 1.1 time = 210
* CHECK dout0_10 vdout0_10ck41 = 0 time = 210
* CHECK dout0_11 vdout0_11ck41 = 1.1 time = 210
* CHECK dout0_12 vdout0_12ck41 = 1.1 time = 210
* CHECK dout0_13 vdout0_13ck41 = 1.1 time = 210
* CHECK dout0_14 vdout0_14ck41 = 0 time = 210
* CHECK dout0_15 vdout0_15ck41 = 1.1 time = 210
* CHECK dout0_16 vdout0_16ck41 = 1.1 time = 210
* CHECK dout0_17 vdout0_17ck41 = 0 time = 210
* CHECK dout0_18 vdout0_18ck41 = 1.1 time = 210
* CHECK dout0_19 vdout0_19ck41 = 0 time = 210
* CHECK dout0_20 vdout0_20ck41 = 0 time = 210
* CHECK dout0_21 vdout0_21ck41 = 0 time = 210
* CHECK dout0_22 vdout0_22ck41 = 0 time = 210
* CHECK dout0_23 vdout0_23ck41 = 0 time = 210
* CHECK dout0_24 vdout0_24ck41 = 1.1 time = 210
* CHECK dout0_25 vdout0_25ck41 = 1.1 time = 210
* CHECK dout0_26 vdout0_26ck41 = 1.1 time = 210
* CHECK dout0_27 vdout0_27ck41 = 0 time = 210
* CHECK dout0_28 vdout0_28ck41 = 0 time = 210
* CHECK dout0_29 vdout0_29ck41 = 0 time = 210
* CHECK dout0_30 vdout0_30ck41 = 0 time = 210
* CHECK dout0_31 vdout0_31ck41 = 1.1 time = 210
* CHECK dout0_0 vdout0_0ck43 = 1.1 time = 220
* CHECK dout0_1 vdout0_1ck43 = 1.1 time = 220
* CHECK dout0_2 vdout0_2ck43 = 0 time = 220
* CHECK dout0_3 vdout0_3ck43 = 0 time = 220
* CHECK dout0_4 vdout0_4ck43 = 0 time = 220
* CHECK dout0_5 vdout0_5ck43 = 1.1 time = 220
* CHECK dout0_6 vdout0_6ck43 = 0 time = 220
* CHECK dout0_7 vdout0_7ck43 = 0 time = 220
* CHECK dout0_8 vdout0_8ck43 = 1.1 time = 220
* CHECK dout0_9 vdout0_9ck43 = 1.1 time = 220
* CHECK dout0_10 vdout0_10ck43 = 0 time = 220
* CHECK dout0_11 vdout0_11ck43 = 1.1 time = 220
* CHECK dout0_12 vdout0_12ck43 = 0 time = 220
* CHECK dout0_13 vdout0_13ck43 = 0 time = 220
* CHECK dout0_14 vdout0_14ck43 = 1.1 time = 220
* CHECK dout0_15 vdout0_15ck43 = 1.1 time = 220
* CHECK dout0_16 vdout0_16ck43 = 0 time = 220
* CHECK dout0_17 vdout0_17ck43 = 1.1 time = 220
* CHECK dout0_18 vdout0_18ck43 = 0 time = 220
* CHECK dout0_19 vdout0_19ck43 = 1.1 time = 220
* CHECK dout0_20 vdout0_20ck43 = 1.1 time = 220
* CHECK dout0_21 vdout0_21ck43 = 1.1 time = 220
* CHECK dout0_22 vdout0_22ck43 = 0 time = 220
* CHECK dout0_23 vdout0_23ck43 = 1.1 time = 220
* CHECK dout0_24 vdout0_24ck43 = 1.1 time = 220
* CHECK dout0_25 vdout0_25ck43 = 0 time = 220
* CHECK dout0_26 vdout0_26ck43 = 0 time = 220
* CHECK dout0_27 vdout0_27ck43 = 0 time = 220
* CHECK dout0_28 vdout0_28ck43 = 0 time = 220
* CHECK dout0_29 vdout0_29ck43 = 0 time = 220
* CHECK dout0_30 vdout0_30ck43 = 1.1 time = 220
* CHECK dout0_31 vdout0_31ck43 = 1.1 time = 220
* CHECK dout0_0 vdout0_0ck44 = 1.1 time = 225
* CHECK dout0_1 vdout0_1ck44 = 1.1 time = 225
* CHECK dout0_2 vdout0_2ck44 = 1.1 time = 225
* CHECK dout0_3 vdout0_3ck44 = 1.1 time = 225
* CHECK dout0_4 vdout0_4ck44 = 0 time = 225
* CHECK dout0_5 vdout0_5ck44 = 0 time = 225
* CHECK dout0_6 vdout0_6ck44 = 0 time = 225
* CHECK dout0_7 vdout0_7ck44 = 0 time = 225
* CHECK dout0_8 vdout0_8ck44 = 0 time = 225
* CHECK dout0_9 vdout0_9ck44 = 0 time = 225
* CHECK dout0_10 vdout0_10ck44 = 1.1 time = 225
* CHECK dout0_11 vdout0_11ck44 = 0 time = 225
* CHECK dout0_12 vdout0_12ck44 = 0 time = 225
* CHECK dout0_13 vdout0_13ck44 = 1.1 time = 225
* CHECK dout0_14 vdout0_14ck44 = 1.1 time = 225
* CHECK dout0_15 vdout0_15ck44 = 1.1 time = 225
* CHECK dout0_16 vdout0_16ck44 = 1.1 time = 225
* CHECK dout0_17 vdout0_17ck44 = 0 time = 225
* CHECK dout0_18 vdout0_18ck44 = 0 time = 225
* CHECK dout0_19 vdout0_19ck44 = 1.1 time = 225
* CHECK dout0_20 vdout0_20ck44 = 0 time = 225
* CHECK dout0_21 vdout0_21ck44 = 1.1 time = 225
* CHECK dout0_22 vdout0_22ck44 = 1.1 time = 225
* CHECK dout0_23 vdout0_23ck44 = 1.1 time = 225
* CHECK dout0_24 vdout0_24ck44 = 1.1 time = 225
* CHECK dout0_25 vdout0_25ck44 = 1.1 time = 225
* CHECK dout0_26 vdout0_26ck44 = 1.1 time = 225
* CHECK dout0_27 vdout0_27ck44 = 0 time = 225
* CHECK dout0_28 vdout0_28ck44 = 1.1 time = 225
* CHECK dout0_29 vdout0_29ck44 = 1.1 time = 225
* CHECK dout0_30 vdout0_30ck44 = 1.1 time = 225
* CHECK dout0_31 vdout0_31ck44 = 0 time = 225
* CHECK dout0_0 vdout0_0ck46 = 1.1 time = 235
* CHECK dout0_1 vdout0_1ck46 = 1.1 time = 235
* CHECK dout0_2 vdout0_2ck46 = 1.1 time = 235
* CHECK dout0_3 vdout0_3ck46 = 0 time = 235
* CHECK dout0_4 vdout0_4ck46 = 1.1 time = 235
* CHECK dout0_5 vdout0_5ck46 = 1.1 time = 235
* CHECK dout0_6 vdout0_6ck46 = 1.1 time = 235
* CHECK dout0_7 vdout0_7ck46 = 1.1 time = 235
* CHECK dout0_8 vdout0_8ck46 = 1.1 time = 235
* CHECK dout0_9 vdout0_9ck46 = 1.1 time = 235
* CHECK dout0_10 vdout0_10ck46 = 0 time = 235
* CHECK dout0_11 vdout0_11ck46 = 1.1 time = 235
* CHECK dout0_12 vdout0_12ck46 = 0 time = 235
* CHECK dout0_13 vdout0_13ck46 = 1.1 time = 235
* CHECK dout0_14 vdout0_14ck46 = 1.1 time = 235
* CHECK dout0_15 vdout0_15ck46 = 0 time = 235
* CHECK dout0_16 vdout0_16ck46 = 1.1 time = 235
* CHECK dout0_17 vdout0_17ck46 = 1.1 time = 235
* CHECK dout0_18 vdout0_18ck46 = 1.1 time = 235
* CHECK dout0_19 vdout0_19ck46 = 0 time = 235
* CHECK dout0_20 vdout0_20ck46 = 1.1 time = 235
* CHECK dout0_21 vdout0_21ck46 = 1.1 time = 235
* CHECK dout0_22 vdout0_22ck46 = 1.1 time = 235
* CHECK dout0_23 vdout0_23ck46 = 1.1 time = 235
* CHECK dout0_24 vdout0_24ck46 = 1.1 time = 235
* CHECK dout0_25 vdout0_25ck46 = 1.1 time = 235
* CHECK dout0_26 vdout0_26ck46 = 1.1 time = 235
* CHECK dout0_27 vdout0_27ck46 = 1.1 time = 235
* CHECK dout0_28 vdout0_28ck46 = 1.1 time = 235
* CHECK dout0_29 vdout0_29ck46 = 1.1 time = 235
* CHECK dout0_30 vdout0_30ck46 = 1.1 time = 235
* CHECK dout0_31 vdout0_31ck46 = 1.1 time = 235
* CHECK dout0_0 vdout0_0ck48 = 1.1 time = 245
* CHECK dout0_1 vdout0_1ck48 = 1.1 time = 245
* CHECK dout0_2 vdout0_2ck48 = 1.1 time = 245
* CHECK dout0_3 vdout0_3ck48 = 0 time = 245
* CHECK dout0_4 vdout0_4ck48 = 1.1 time = 245
* CHECK dout0_5 vdout0_5ck48 = 1.1 time = 245
* CHECK dout0_6 vdout0_6ck48 = 1.1 time = 245
* CHECK dout0_7 vdout0_7ck48 = 1.1 time = 245
* CHECK dout0_8 vdout0_8ck48 = 1.1 time = 245
* CHECK dout0_9 vdout0_9ck48 = 1.1 time = 245
* CHECK dout0_10 vdout0_10ck48 = 0 time = 245
* CHECK dout0_11 vdout0_11ck48 = 1.1 time = 245
* CHECK dout0_12 vdout0_12ck48 = 0 time = 245
* CHECK dout0_13 vdout0_13ck48 = 1.1 time = 245
* CHECK dout0_14 vdout0_14ck48 = 1.1 time = 245
* CHECK dout0_15 vdout0_15ck48 = 0 time = 245
* CHECK dout0_16 vdout0_16ck48 = 1.1 time = 245
* CHECK dout0_17 vdout0_17ck48 = 1.1 time = 245
* CHECK dout0_18 vdout0_18ck48 = 1.1 time = 245
* CHECK dout0_19 vdout0_19ck48 = 0 time = 245
* CHECK dout0_20 vdout0_20ck48 = 1.1 time = 245
* CHECK dout0_21 vdout0_21ck48 = 1.1 time = 245
* CHECK dout0_22 vdout0_22ck48 = 1.1 time = 245
* CHECK dout0_23 vdout0_23ck48 = 1.1 time = 245
* CHECK dout0_24 vdout0_24ck48 = 1.1 time = 245
* CHECK dout0_25 vdout0_25ck48 = 1.1 time = 245
* CHECK dout0_26 vdout0_26ck48 = 1.1 time = 245
* CHECK dout0_27 vdout0_27ck48 = 1.1 time = 245
* CHECK dout0_28 vdout0_28ck48 = 1.1 time = 245
* CHECK dout0_29 vdout0_29ck48 = 1.1 time = 245
* CHECK dout0_30 vdout0_30ck48 = 1.1 time = 245
* CHECK dout0_31 vdout0_31ck48 = 1.1 time = 245
* CHECK dout0_0 vdout0_0ck50 = 0 time = 255
* CHECK dout0_1 vdout0_1ck50 = 0 time = 255
* CHECK dout0_2 vdout0_2ck50 = 0 time = 255
* CHECK dout0_3 vdout0_3ck50 = 1.1 time = 255
* CHECK dout0_4 vdout0_4ck50 = 1.1 time = 255
* CHECK dout0_5 vdout0_5ck50 = 0 time = 255
* CHECK dout0_6 vdout0_6ck50 = 0 time = 255
* CHECK dout0_7 vdout0_7ck50 = 0 time = 255
* CHECK dout0_8 vdout0_8ck50 = 1.1 time = 255
* CHECK dout0_9 vdout0_9ck50 = 1.1 time = 255
* CHECK dout0_10 vdout0_10ck50 = 0 time = 255
* CHECK dout0_11 vdout0_11ck50 = 0 time = 255
* CHECK dout0_12 vdout0_12ck50 = 0 time = 255
* CHECK dout0_13 vdout0_13ck50 = 0 time = 255
* CHECK dout0_14 vdout0_14ck50 = 1.1 time = 255
* CHECK dout0_15 vdout0_15ck50 = 1.1 time = 255
* CHECK dout0_16 vdout0_16ck50 = 0 time = 255
* CHECK dout0_17 vdout0_17ck50 = 0 time = 255
* CHECK dout0_18 vdout0_18ck50 = 0 time = 255
* CHECK dout0_19 vdout0_19ck50 = 1.1 time = 255
* CHECK dout0_20 vdout0_20ck50 = 0 time = 255
* CHECK dout0_21 vdout0_21ck50 = 0 time = 255
* CHECK dout0_22 vdout0_22ck50 = 0 time = 255
* CHECK dout0_23 vdout0_23ck50 = 0 time = 255
* CHECK dout0_24 vdout0_24ck50 = 1.1 time = 255
* CHECK dout0_25 vdout0_25ck50 = 0 time = 255
* CHECK dout0_26 vdout0_26ck50 = 0 time = 255
* CHECK dout0_27 vdout0_27ck50 = 0 time = 255
* CHECK dout0_28 vdout0_28ck50 = 0 time = 255
* CHECK dout0_29 vdout0_29ck50 = 1.1 time = 255
* CHECK dout0_30 vdout0_30ck50 = 0 time = 255
* CHECK dout0_31 vdout0_31ck50 = 0 time = 255
* CHECK dout0_0 vdout0_0ck51 = 0 time = 260
* CHECK dout0_1 vdout0_1ck51 = 1.1 time = 260
* CHECK dout0_2 vdout0_2ck51 = 1.1 time = 260
* CHECK dout0_3 vdout0_3ck51 = 1.1 time = 260
* CHECK dout0_4 vdout0_4ck51 = 1.1 time = 260
* CHECK dout0_5 vdout0_5ck51 = 1.1 time = 260
* CHECK dout0_6 vdout0_6ck51 = 0 time = 260
* CHECK dout0_7 vdout0_7ck51 = 1.1 time = 260
* CHECK dout0_8 vdout0_8ck51 = 0 time = 260
* CHECK dout0_9 vdout0_9ck51 = 1.1 time = 260
* CHECK dout0_10 vdout0_10ck51 = 0 time = 260
* CHECK dout0_11 vdout0_11ck51 = 1.1 time = 260
* CHECK dout0_12 vdout0_12ck51 = 0 time = 260
* CHECK dout0_13 vdout0_13ck51 = 1.1 time = 260
* CHECK dout0_14 vdout0_14ck51 = 0 time = 260
* CHECK dout0_15 vdout0_15ck51 = 1.1 time = 260
* CHECK dout0_16 vdout0_16ck51 = 0 time = 260
* CHECK dout0_17 vdout0_17ck51 = 1.1 time = 260
* CHECK dout0_18 vdout0_18ck51 = 1.1 time = 260
* CHECK dout0_19 vdout0_19ck51 = 1.1 time = 260
* CHECK dout0_20 vdout0_20ck51 = 0 time = 260
* CHECK dout0_21 vdout0_21ck51 = 0 time = 260
* CHECK dout0_22 vdout0_22ck51 = 1.1 time = 260
* CHECK dout0_23 vdout0_23ck51 = 0 time = 260
* CHECK dout0_24 vdout0_24ck51 = 0 time = 260
* CHECK dout0_25 vdout0_25ck51 = 0 time = 260
* CHECK dout0_26 vdout0_26ck51 = 0 time = 260
* CHECK dout0_27 vdout0_27ck51 = 0 time = 260
* CHECK dout0_28 vdout0_28ck51 = 0 time = 260
* CHECK dout0_29 vdout0_29ck51 = 0 time = 260
* CHECK dout0_30 vdout0_30ck51 = 1.1 time = 260
* CHECK dout0_31 vdout0_31ck51 = 0 time = 260
* CHECK dout0_0 vdout0_0ck55 = 1.1 time = 280
* CHECK dout0_1 vdout0_1ck55 = 1.1 time = 280
* CHECK dout0_2 vdout0_2ck55 = 1.1 time = 280
* CHECK dout0_3 vdout0_3ck55 = 1.1 time = 280
* CHECK dout0_4 vdout0_4ck55 = 0 time = 280
* CHECK dout0_5 vdout0_5ck55 = 0 time = 280
* CHECK dout0_6 vdout0_6ck55 = 0 time = 280
* CHECK dout0_7 vdout0_7ck55 = 0 time = 280
* CHECK dout0_8 vdout0_8ck55 = 0 time = 280
* CHECK dout0_9 vdout0_9ck55 = 0 time = 280
* CHECK dout0_10 vdout0_10ck55 = 1.1 time = 280
* CHECK dout0_11 vdout0_11ck55 = 0 time = 280
* CHECK dout0_12 vdout0_12ck55 = 0 time = 280
* CHECK dout0_13 vdout0_13ck55 = 1.1 time = 280
* CHECK dout0_14 vdout0_14ck55 = 1.1 time = 280
* CHECK dout0_15 vdout0_15ck55 = 1.1 time = 280
* CHECK dout0_16 vdout0_16ck55 = 1.1 time = 280
* CHECK dout0_17 vdout0_17ck55 = 0 time = 280
* CHECK dout0_18 vdout0_18ck55 = 0 time = 280
* CHECK dout0_19 vdout0_19ck55 = 1.1 time = 280
* CHECK dout0_20 vdout0_20ck55 = 0 time = 280
* CHECK dout0_21 vdout0_21ck55 = 1.1 time = 280
* CHECK dout0_22 vdout0_22ck55 = 1.1 time = 280
* CHECK dout0_23 vdout0_23ck55 = 1.1 time = 280
* CHECK dout0_24 vdout0_24ck55 = 1.1 time = 280
* CHECK dout0_25 vdout0_25ck55 = 1.1 time = 280
* CHECK dout0_26 vdout0_26ck55 = 1.1 time = 280
* CHECK dout0_27 vdout0_27ck55 = 0 time = 280
* CHECK dout0_28 vdout0_28ck55 = 1.1 time = 280
* CHECK dout0_29 vdout0_29ck55 = 1.1 time = 280
* CHECK dout0_30 vdout0_30ck55 = 1.1 time = 280
* CHECK dout0_31 vdout0_31ck55 = 0 time = 280
* CHECK dout0_0 vdout0_0ck56 = 0 time = 285
* CHECK dout0_1 vdout0_1ck56 = 0 time = 285
* CHECK dout0_2 vdout0_2ck56 = 1.1 time = 285
* CHECK dout0_3 vdout0_3ck56 = 1.1 time = 285
* CHECK dout0_4 vdout0_4ck56 = 0 time = 285
* CHECK dout0_5 vdout0_5ck56 = 0 time = 285
* CHECK dout0_6 vdout0_6ck56 = 1.1 time = 285
* CHECK dout0_7 vdout0_7ck56 = 1.1 time = 285
* CHECK dout0_8 vdout0_8ck56 = 0 time = 285
* CHECK dout0_9 vdout0_9ck56 = 1.1 time = 285
* CHECK dout0_10 vdout0_10ck56 = 0 time = 285
* CHECK dout0_11 vdout0_11ck56 = 1.1 time = 285
* CHECK dout0_12 vdout0_12ck56 = 1.1 time = 285
* CHECK dout0_13 vdout0_13ck56 = 1.1 time = 285
* CHECK dout0_14 vdout0_14ck56 = 0 time = 285
* CHECK dout0_15 vdout0_15ck56 = 0 time = 285
* CHECK dout0_16 vdout0_16ck56 = 1.1 time = 285
* CHECK dout0_17 vdout0_17ck56 = 1.1 time = 285
* CHECK dout0_18 vdout0_18ck56 = 0 time = 285
* CHECK dout0_19 vdout0_19ck56 = 1.1 time = 285
* CHECK dout0_20 vdout0_20ck56 = 1.1 time = 285
* CHECK dout0_21 vdout0_21ck56 = 1.1 time = 285
* CHECK dout0_22 vdout0_22ck56 = 1.1 time = 285
* CHECK dout0_23 vdout0_23ck56 = 0 time = 285
* CHECK dout0_24 vdout0_24ck56 = 1.1 time = 285
* CHECK dout0_25 vdout0_25ck56 = 1.1 time = 285
* CHECK dout0_26 vdout0_26ck56 = 1.1 time = 285
* CHECK dout0_27 vdout0_27ck56 = 1.1 time = 285
* CHECK dout0_28 vdout0_28ck56 = 0 time = 285
* CHECK dout0_29 vdout0_29ck56 = 0 time = 285
* CHECK dout0_30 vdout0_30ck56 = 1.1 time = 285
* CHECK dout0_31 vdout0_31ck56 = 0 time = 285
* CHECK dout0_0 vdout0_0ck57 = 0 time = 290
* CHECK dout0_1 vdout0_1ck57 = 0 time = 290
* CHECK dout0_2 vdout0_2ck57 = 1.1 time = 290
* CHECK dout0_3 vdout0_3ck57 = 1.1 time = 290
* CHECK dout0_4 vdout0_4ck57 = 0 time = 290
* CHECK dout0_5 vdout0_5ck57 = 0 time = 290
* CHECK dout0_6 vdout0_6ck57 = 1.1 time = 290
* CHECK dout0_7 vdout0_7ck57 = 1.1 time = 290
* CHECK dout0_8 vdout0_8ck57 = 0 time = 290
* CHECK dout0_9 vdout0_9ck57 = 1.1 time = 290
* CHECK dout0_10 vdout0_10ck57 = 0 time = 290
* CHECK dout0_11 vdout0_11ck57 = 1.1 time = 290
* CHECK dout0_12 vdout0_12ck57 = 1.1 time = 290
* CHECK dout0_13 vdout0_13ck57 = 1.1 time = 290
* CHECK dout0_14 vdout0_14ck57 = 0 time = 290
* CHECK dout0_15 vdout0_15ck57 = 0 time = 290
* CHECK dout0_16 vdout0_16ck57 = 1.1 time = 290
* CHECK dout0_17 vdout0_17ck57 = 1.1 time = 290
* CHECK dout0_18 vdout0_18ck57 = 0 time = 290
* CHECK dout0_19 vdout0_19ck57 = 1.1 time = 290
* CHECK dout0_20 vdout0_20ck57 = 1.1 time = 290
* CHECK dout0_21 vdout0_21ck57 = 1.1 time = 290
* CHECK dout0_22 vdout0_22ck57 = 1.1 time = 290
* CHECK dout0_23 vdout0_23ck57 = 0 time = 290
* CHECK dout0_24 vdout0_24ck57 = 1.1 time = 290
* CHECK dout0_25 vdout0_25ck57 = 1.1 time = 290
* CHECK dout0_26 vdout0_26ck57 = 1.1 time = 290
* CHECK dout0_27 vdout0_27ck57 = 1.1 time = 290
* CHECK dout0_28 vdout0_28ck57 = 0 time = 290
* CHECK dout0_29 vdout0_29ck57 = 0 time = 290
* CHECK dout0_30 vdout0_30ck57 = 1.1 time = 290
* CHECK dout0_31 vdout0_31ck57 = 0 time = 290
* CHECK dout0_0 vdout0_0ck58 = 1.1 time = 295
* CHECK dout0_1 vdout0_1ck58 = 1.1 time = 295
* CHECK dout0_2 vdout0_2ck58 = 1.1 time = 295
* CHECK dout0_3 vdout0_3ck58 = 1.1 time = 295
* CHECK dout0_4 vdout0_4ck58 = 0 time = 295
* CHECK dout0_5 vdout0_5ck58 = 0 time = 295
* CHECK dout0_6 vdout0_6ck58 = 0 time = 295
* CHECK dout0_7 vdout0_7ck58 = 0 time = 295
* CHECK dout0_8 vdout0_8ck58 = 0 time = 295
* CHECK dout0_9 vdout0_9ck58 = 0 time = 295
* CHECK dout0_10 vdout0_10ck58 = 1.1 time = 295
* CHECK dout0_11 vdout0_11ck58 = 0 time = 295
* CHECK dout0_12 vdout0_12ck58 = 0 time = 295
* CHECK dout0_13 vdout0_13ck58 = 1.1 time = 295
* CHECK dout0_14 vdout0_14ck58 = 1.1 time = 295
* CHECK dout0_15 vdout0_15ck58 = 1.1 time = 295
* CHECK dout0_16 vdout0_16ck58 = 1.1 time = 295
* CHECK dout0_17 vdout0_17ck58 = 0 time = 295
* CHECK dout0_18 vdout0_18ck58 = 0 time = 295
* CHECK dout0_19 vdout0_19ck58 = 1.1 time = 295
* CHECK dout0_20 vdout0_20ck58 = 0 time = 295
* CHECK dout0_21 vdout0_21ck58 = 1.1 time = 295
* CHECK dout0_22 vdout0_22ck58 = 1.1 time = 295
* CHECK dout0_23 vdout0_23ck58 = 1.1 time = 295
* CHECK dout0_24 vdout0_24ck58 = 1.1 time = 295
* CHECK dout0_25 vdout0_25ck58 = 1.1 time = 295
* CHECK dout0_26 vdout0_26ck58 = 1.1 time = 295
* CHECK dout0_27 vdout0_27ck58 = 0 time = 295
* CHECK dout0_28 vdout0_28ck58 = 1.1 time = 295
* CHECK dout0_29 vdout0_29ck58 = 1.1 time = 295
* CHECK dout0_30 vdout0_30ck58 = 1.1 time = 295
* CHECK dout0_31 vdout0_31ck58 = 0 time = 295
* CHECK dout0_0 vdout0_0ck60 = 0 time = 305
* CHECK dout0_1 vdout0_1ck60 = 1.1 time = 305
* CHECK dout0_2 vdout0_2ck60 = 1.1 time = 305
* CHECK dout0_3 vdout0_3ck60 = 1.1 time = 305
* CHECK dout0_4 vdout0_4ck60 = 1.1 time = 305
* CHECK dout0_5 vdout0_5ck60 = 1.1 time = 305
* CHECK dout0_6 vdout0_6ck60 = 0 time = 305
* CHECK dout0_7 vdout0_7ck60 = 1.1 time = 305
* CHECK dout0_8 vdout0_8ck60 = 0 time = 305
* CHECK dout0_9 vdout0_9ck60 = 1.1 time = 305
* CHECK dout0_10 vdout0_10ck60 = 0 time = 305
* CHECK dout0_11 vdout0_11ck60 = 1.1 time = 305
* CHECK dout0_12 vdout0_12ck60 = 0 time = 305
* CHECK dout0_13 vdout0_13ck60 = 1.1 time = 305
* CHECK dout0_14 vdout0_14ck60 = 0 time = 305
* CHECK dout0_15 vdout0_15ck60 = 1.1 time = 305
* CHECK dout0_16 vdout0_16ck60 = 0 time = 305
* CHECK dout0_17 vdout0_17ck60 = 1.1 time = 305
* CHECK dout0_18 vdout0_18ck60 = 1.1 time = 305
* CHECK dout0_19 vdout0_19ck60 = 1.1 time = 305
* CHECK dout0_20 vdout0_20ck60 = 0 time = 305
* CHECK dout0_21 vdout0_21ck60 = 0 time = 305
* CHECK dout0_22 vdout0_22ck60 = 1.1 time = 305
* CHECK dout0_23 vdout0_23ck60 = 0 time = 305
* CHECK dout0_24 vdout0_24ck60 = 0 time = 305
* CHECK dout0_25 vdout0_25ck60 = 0 time = 305
* CHECK dout0_26 vdout0_26ck60 = 0 time = 305
* CHECK dout0_27 vdout0_27ck60 = 0 time = 305
* CHECK dout0_28 vdout0_28ck60 = 0 time = 305
* CHECK dout0_29 vdout0_29ck60 = 0 time = 305
* CHECK dout0_30 vdout0_30ck60 = 1.1 time = 305
* CHECK dout0_31 vdout0_31ck60 = 0 time = 305
* CHECK dout0_0 vdout0_0ck61 = 1.1 time = 310
* CHECK dout0_1 vdout0_1ck61 = 1.1 time = 310
* CHECK dout0_2 vdout0_2ck61 = 0 time = 310
* CHECK dout0_3 vdout0_3ck61 = 0 time = 310
* CHECK dout0_4 vdout0_4ck61 = 0 time = 310
* CHECK dout0_5 vdout0_5ck61 = 1.1 time = 310
* CHECK dout0_6 vdout0_6ck61 = 0 time = 310
* CHECK dout0_7 vdout0_7ck61 = 0 time = 310
* CHECK dout0_8 vdout0_8ck61 = 1.1 time = 310
* CHECK dout0_9 vdout0_9ck61 = 1.1 time = 310
* CHECK dout0_10 vdout0_10ck61 = 0 time = 310
* CHECK dout0_11 vdout0_11ck61 = 1.1 time = 310
* CHECK dout0_12 vdout0_12ck61 = 0 time = 310
* CHECK dout0_13 vdout0_13ck61 = 0 time = 310
* CHECK dout0_14 vdout0_14ck61 = 1.1 time = 310
* CHECK dout0_15 vdout0_15ck61 = 1.1 time = 310
* CHECK dout0_16 vdout0_16ck61 = 0 time = 310
* CHECK dout0_17 vdout0_17ck61 = 1.1 time = 310
* CHECK dout0_18 vdout0_18ck61 = 0 time = 310
* CHECK dout0_19 vdout0_19ck61 = 1.1 time = 310
* CHECK dout0_20 vdout0_20ck61 = 1.1 time = 310
* CHECK dout0_21 vdout0_21ck61 = 1.1 time = 310
* CHECK dout0_22 vdout0_22ck61 = 0 time = 310
* CHECK dout0_23 vdout0_23ck61 = 1.1 time = 310
* CHECK dout0_24 vdout0_24ck61 = 1.1 time = 310
* CHECK dout0_25 vdout0_25ck61 = 0 time = 310
* CHECK dout0_26 vdout0_26ck61 = 0 time = 310
* CHECK dout0_27 vdout0_27ck61 = 0 time = 310
* CHECK dout0_28 vdout0_28ck61 = 0 time = 310
* CHECK dout0_29 vdout0_29ck61 = 0 time = 310
* CHECK dout0_30 vdout0_30ck61 = 1.1 time = 310
* CHECK dout0_31 vdout0_31ck61 = 1.1 time = 310
* CHECK dout0_0 vdout0_0ck63 = 1.1 time = 320
* CHECK dout0_1 vdout0_1ck63 = 1.1 time = 320
* CHECK dout0_2 vdout0_2ck63 = 1.1 time = 320
* CHECK dout0_3 vdout0_3ck63 = 0 time = 320
* CHECK dout0_4 vdout0_4ck63 = 0 time = 320
* CHECK dout0_5 vdout0_5ck63 = 1.1 time = 320
* CHECK dout0_6 vdout0_6ck63 = 0 time = 320
* CHECK dout0_7 vdout0_7ck63 = 0 time = 320
* CHECK dout0_8 vdout0_8ck63 = 1.1 time = 320
* CHECK dout0_9 vdout0_9ck63 = 1.1 time = 320
* CHECK dout0_10 vdout0_10ck63 = 1.1 time = 320
* CHECK dout0_11 vdout0_11ck63 = 1.1 time = 320
* CHECK dout0_12 vdout0_12ck63 = 0 time = 320
* CHECK dout0_13 vdout0_13ck63 = 1.1 time = 320
* CHECK dout0_14 vdout0_14ck63 = 1.1 time = 320
* CHECK dout0_15 vdout0_15ck63 = 1.1 time = 320
* CHECK dout0_16 vdout0_16ck63 = 1.1 time = 320
* CHECK dout0_17 vdout0_17ck63 = 1.1 time = 320
* CHECK dout0_18 vdout0_18ck63 = 0 time = 320
* CHECK dout0_19 vdout0_19ck63 = 1.1 time = 320
* CHECK dout0_20 vdout0_20ck63 = 1.1 time = 320
* CHECK dout0_21 vdout0_21ck63 = 0 time = 320
* CHECK dout0_22 vdout0_22ck63 = 1.1 time = 320
* CHECK dout0_23 vdout0_23ck63 = 1.1 time = 320
* CHECK dout0_24 vdout0_24ck63 = 0 time = 320
* CHECK dout0_25 vdout0_25ck63 = 1.1 time = 320
* CHECK dout0_26 vdout0_26ck63 = 1.1 time = 320
* CHECK dout0_27 vdout0_27ck63 = 0 time = 320
* CHECK dout0_28 vdout0_28ck63 = 1.1 time = 320
* CHECK dout0_29 vdout0_29ck63 = 1.1 time = 320
* CHECK dout0_30 vdout0_30ck63 = 0 time = 320
* CHECK dout0_31 vdout0_31ck63 = 0 time = 320
* CHECK dout0_0 vdout0_0ck64 = 0 time = 325
* CHECK dout0_1 vdout0_1ck64 = 0 time = 325
* CHECK dout0_2 vdout0_2ck64 = 1.1 time = 325
* CHECK dout0_3 vdout0_3ck64 = 1.1 time = 325
* CHECK dout0_4 vdout0_4ck64 = 0 time = 325
* CHECK dout0_5 vdout0_5ck64 = 0 time = 325
* CHECK dout0_6 vdout0_6ck64 = 1.1 time = 325
* CHECK dout0_7 vdout0_7ck64 = 1.1 time = 325
* CHECK dout0_8 vdout0_8ck64 = 0 time = 325
* CHECK dout0_9 vdout0_9ck64 = 1.1 time = 325
* CHECK dout0_10 vdout0_10ck64 = 0 time = 325
* CHECK dout0_11 vdout0_11ck64 = 1.1 time = 325
* CHECK dout0_12 vdout0_12ck64 = 1.1 time = 325
* CHECK dout0_13 vdout0_13ck64 = 1.1 time = 325
* CHECK dout0_14 vdout0_14ck64 = 0 time = 325
* CHECK dout0_15 vdout0_15ck64 = 0 time = 325
* CHECK dout0_16 vdout0_16ck64 = 1.1 time = 325
* CHECK dout0_17 vdout0_17ck64 = 1.1 time = 325
* CHECK dout0_18 vdout0_18ck64 = 0 time = 325
* CHECK dout0_19 vdout0_19ck64 = 1.1 time = 325
* CHECK dout0_20 vdout0_20ck64 = 1.1 time = 325
* CHECK dout0_21 vdout0_21ck64 = 1.1 time = 325
* CHECK dout0_22 vdout0_22ck64 = 1.1 time = 325
* CHECK dout0_23 vdout0_23ck64 = 0 time = 325
* CHECK dout0_24 vdout0_24ck64 = 1.1 time = 325
* CHECK dout0_25 vdout0_25ck64 = 1.1 time = 325
* CHECK dout0_26 vdout0_26ck64 = 1.1 time = 325
* CHECK dout0_27 vdout0_27ck64 = 1.1 time = 325
* CHECK dout0_28 vdout0_28ck64 = 0 time = 325
* CHECK dout0_29 vdout0_29ck64 = 0 time = 325
* CHECK dout0_30 vdout0_30ck64 = 1.1 time = 325
* CHECK dout0_31 vdout0_31ck64 = 0 time = 325
* CHECK dout0_0 vdout0_0ck66 = 1.1 time = 335
* CHECK dout0_1 vdout0_1ck66 = 1.1 time = 335
* CHECK dout0_2 vdout0_2ck66 = 1.1 time = 335
* CHECK dout0_3 vdout0_3ck66 = 1.1 time = 335
* CHECK dout0_4 vdout0_4ck66 = 0 time = 335
* CHECK dout0_5 vdout0_5ck66 = 0 time = 335
* CHECK dout0_6 vdout0_6ck66 = 1.1 time = 335
* CHECK dout0_7 vdout0_7ck66 = 0 time = 335
* CHECK dout0_8 vdout0_8ck66 = 1.1 time = 335
* CHECK dout0_9 vdout0_9ck66 = 0 time = 335
* CHECK dout0_10 vdout0_10ck66 = 1.1 time = 335
* CHECK dout0_11 vdout0_11ck66 = 1.1 time = 335
* CHECK dout0_12 vdout0_12ck66 = 0 time = 335
* CHECK dout0_13 vdout0_13ck66 = 0 time = 335
* CHECK dout0_14 vdout0_14ck66 = 1.1 time = 335
* CHECK dout0_15 vdout0_15ck66 = 1.1 time = 335
* CHECK dout0_16 vdout0_16ck66 = 0 time = 335
* CHECK dout0_17 vdout0_17ck66 = 1.1 time = 335
* CHECK dout0_18 vdout0_18ck66 = 0 time = 335
* CHECK dout0_19 vdout0_19ck66 = 0 time = 335
* CHECK dout0_20 vdout0_20ck66 = 1.1 time = 335
* CHECK dout0_21 vdout0_21ck66 = 0 time = 335
* CHECK dout0_22 vdout0_22ck66 = 0 time = 335
* CHECK dout0_23 vdout0_23ck66 = 0 time = 335
* CHECK dout0_24 vdout0_24ck66 = 0 time = 335
* CHECK dout0_25 vdout0_25ck66 = 0 time = 335
* CHECK dout0_26 vdout0_26ck66 = 1.1 time = 335
* CHECK dout0_27 vdout0_27ck66 = 1.1 time = 335
* CHECK dout0_28 vdout0_28ck66 = 0 time = 335
* CHECK dout0_29 vdout0_29ck66 = 1.1 time = 335
* CHECK dout0_30 vdout0_30ck66 = 1.1 time = 335
* CHECK dout0_31 vdout0_31ck66 = 1.1 time = 335
* CHECK dout0_0 vdout0_0ck68 = 1.1 time = 345
* CHECK dout0_1 vdout0_1ck68 = 1.1 time = 345
* CHECK dout0_2 vdout0_2ck68 = 1.1 time = 345
* CHECK dout0_3 vdout0_3ck68 = 0 time = 345
* CHECK dout0_4 vdout0_4ck68 = 0 time = 345
* CHECK dout0_5 vdout0_5ck68 = 1.1 time = 345
* CHECK dout0_6 vdout0_6ck68 = 0 time = 345
* CHECK dout0_7 vdout0_7ck68 = 0 time = 345
* CHECK dout0_8 vdout0_8ck68 = 1.1 time = 345
* CHECK dout0_9 vdout0_9ck68 = 1.1 time = 345
* CHECK dout0_10 vdout0_10ck68 = 1.1 time = 345
* CHECK dout0_11 vdout0_11ck68 = 1.1 time = 345
* CHECK dout0_12 vdout0_12ck68 = 0 time = 345
* CHECK dout0_13 vdout0_13ck68 = 1.1 time = 345
* CHECK dout0_14 vdout0_14ck68 = 1.1 time = 345
* CHECK dout0_15 vdout0_15ck68 = 1.1 time = 345
* CHECK dout0_16 vdout0_16ck68 = 1.1 time = 345
* CHECK dout0_17 vdout0_17ck68 = 1.1 time = 345
* CHECK dout0_18 vdout0_18ck68 = 0 time = 345
* CHECK dout0_19 vdout0_19ck68 = 1.1 time = 345
* CHECK dout0_20 vdout0_20ck68 = 1.1 time = 345
* CHECK dout0_21 vdout0_21ck68 = 0 time = 345
* CHECK dout0_22 vdout0_22ck68 = 1.1 time = 345
* CHECK dout0_23 vdout0_23ck68 = 1.1 time = 345
* CHECK dout0_24 vdout0_24ck68 = 0 time = 345
* CHECK dout0_25 vdout0_25ck68 = 1.1 time = 345
* CHECK dout0_26 vdout0_26ck68 = 1.1 time = 345
* CHECK dout0_27 vdout0_27ck68 = 0 time = 345
* CHECK dout0_28 vdout0_28ck68 = 1.1 time = 345
* CHECK dout0_29 vdout0_29ck68 = 1.1 time = 345
* CHECK dout0_30 vdout0_30ck68 = 0 time = 345
* CHECK dout0_31 vdout0_31ck68 = 0 time = 345
* CHECK dout0_0 vdout0_0ck69 = 1.1 time = 350
* CHECK dout0_1 vdout0_1ck69 = 1.1 time = 350
* CHECK dout0_2 vdout0_2ck69 = 1.1 time = 350
* CHECK dout0_3 vdout0_3ck69 = 1.1 time = 350
* CHECK dout0_4 vdout0_4ck69 = 0 time = 350
* CHECK dout0_5 vdout0_5ck69 = 0 time = 350
* CHECK dout0_6 vdout0_6ck69 = 0 time = 350
* CHECK dout0_7 vdout0_7ck69 = 0 time = 350
* CHECK dout0_8 vdout0_8ck69 = 0 time = 350
* CHECK dout0_9 vdout0_9ck69 = 0 time = 350
* CHECK dout0_10 vdout0_10ck69 = 1.1 time = 350
* CHECK dout0_11 vdout0_11ck69 = 0 time = 350
* CHECK dout0_12 vdout0_12ck69 = 0 time = 350
* CHECK dout0_13 vdout0_13ck69 = 1.1 time = 350
* CHECK dout0_14 vdout0_14ck69 = 1.1 time = 350
* CHECK dout0_15 vdout0_15ck69 = 1.1 time = 350
* CHECK dout0_16 vdout0_16ck69 = 1.1 time = 350
* CHECK dout0_17 vdout0_17ck69 = 0 time = 350
* CHECK dout0_18 vdout0_18ck69 = 0 time = 350
* CHECK dout0_19 vdout0_19ck69 = 1.1 time = 350
* CHECK dout0_20 vdout0_20ck69 = 0 time = 350
* CHECK dout0_21 vdout0_21ck69 = 1.1 time = 350
* CHECK dout0_22 vdout0_22ck69 = 1.1 time = 350
* CHECK dout0_23 vdout0_23ck69 = 1.1 time = 350
* CHECK dout0_24 vdout0_24ck69 = 1.1 time = 350
* CHECK dout0_25 vdout0_25ck69 = 1.1 time = 350
* CHECK dout0_26 vdout0_26ck69 = 1.1 time = 350
* CHECK dout0_27 vdout0_27ck69 = 0 time = 350
* CHECK dout0_28 vdout0_28ck69 = 1.1 time = 350
* CHECK dout0_29 vdout0_29ck69 = 1.1 time = 350
* CHECK dout0_30 vdout0_30ck69 = 1.1 time = 350
* CHECK dout0_31 vdout0_31ck69 = 0 time = 350
* CHECK dout0_0 vdout0_0ck72 = 0 time = 365
* CHECK dout0_1 vdout0_1ck72 = 0 time = 365
* CHECK dout0_2 vdout0_2ck72 = 1.1 time = 365
* CHECK dout0_3 vdout0_3ck72 = 1.1 time = 365
* CHECK dout0_4 vdout0_4ck72 = 1.1 time = 365
* CHECK dout0_5 vdout0_5ck72 = 0 time = 365
* CHECK dout0_6 vdout0_6ck72 = 1.1 time = 365
* CHECK dout0_7 vdout0_7ck72 = 0 time = 365
* CHECK dout0_8 vdout0_8ck72 = 1.1 time = 365
* CHECK dout0_9 vdout0_9ck72 = 0 time = 365
* CHECK dout0_10 vdout0_10ck72 = 0 time = 365
* CHECK dout0_11 vdout0_11ck72 = 1.1 time = 365
* CHECK dout0_12 vdout0_12ck72 = 1.1 time = 365
* CHECK dout0_13 vdout0_13ck72 = 0 time = 365
* CHECK dout0_14 vdout0_14ck72 = 0 time = 365
* CHECK dout0_15 vdout0_15ck72 = 0 time = 365
* CHECK dout0_16 vdout0_16ck72 = 1.1 time = 365
* CHECK dout0_17 vdout0_17ck72 = 0 time = 365
* CHECK dout0_18 vdout0_18ck72 = 0 time = 365
* CHECK dout0_19 vdout0_19ck72 = 1.1 time = 365
* CHECK dout0_20 vdout0_20ck72 = 1.1 time = 365
* CHECK dout0_21 vdout0_21ck72 = 1.1 time = 365
* CHECK dout0_22 vdout0_22ck72 = 0 time = 365
* CHECK dout0_23 vdout0_23ck72 = 1.1 time = 365
* CHECK dout0_24 vdout0_24ck72 = 1.1 time = 365
* CHECK dout0_25 vdout0_25ck72 = 0 time = 365
* CHECK dout0_26 vdout0_26ck72 = 0 time = 365
* CHECK dout0_27 vdout0_27ck72 = 1.1 time = 365
* CHECK dout0_28 vdout0_28ck72 = 1.1 time = 365
* CHECK dout0_29 vdout0_29ck72 = 0 time = 365
* CHECK dout0_30 vdout0_30ck72 = 0 time = 365
* CHECK dout0_31 vdout0_31ck72 = 1.1 time = 365
* CHECK dout0_0 vdout0_0ck74 = 0 time = 375
* CHECK dout0_1 vdout0_1ck74 = 1.1 time = 375
* CHECK dout0_2 vdout0_2ck74 = 1.1 time = 375
* CHECK dout0_3 vdout0_3ck74 = 1.1 time = 375
* CHECK dout0_4 vdout0_4ck74 = 1.1 time = 375
* CHECK dout0_5 vdout0_5ck74 = 1.1 time = 375
* CHECK dout0_6 vdout0_6ck74 = 0 time = 375
* CHECK dout0_7 vdout0_7ck74 = 1.1 time = 375
* CHECK dout0_8 vdout0_8ck74 = 0 time = 375
* CHECK dout0_9 vdout0_9ck74 = 1.1 time = 375
* CHECK dout0_10 vdout0_10ck74 = 0 time = 375
* CHECK dout0_11 vdout0_11ck74 = 1.1 time = 375
* CHECK dout0_12 vdout0_12ck74 = 0 time = 375
* CHECK dout0_13 vdout0_13ck74 = 1.1 time = 375
* CHECK dout0_14 vdout0_14ck74 = 0 time = 375
* CHECK dout0_15 vdout0_15ck74 = 1.1 time = 375
* CHECK dout0_16 vdout0_16ck74 = 0 time = 375
* CHECK dout0_17 vdout0_17ck74 = 1.1 time = 375
* CHECK dout0_18 vdout0_18ck74 = 1.1 time = 375
* CHECK dout0_19 vdout0_19ck74 = 1.1 time = 375
* CHECK dout0_20 vdout0_20ck74 = 0 time = 375
* CHECK dout0_21 vdout0_21ck74 = 0 time = 375
* CHECK dout0_22 vdout0_22ck74 = 1.1 time = 375
* CHECK dout0_23 vdout0_23ck74 = 0 time = 375
* CHECK dout0_24 vdout0_24ck74 = 0 time = 375
* CHECK dout0_25 vdout0_25ck74 = 0 time = 375
* CHECK dout0_26 vdout0_26ck74 = 0 time = 375
* CHECK dout0_27 vdout0_27ck74 = 0 time = 375
* CHECK dout0_28 vdout0_28ck74 = 0 time = 375
* CHECK dout0_29 vdout0_29ck74 = 0 time = 375
* CHECK dout0_30 vdout0_30ck74 = 1.1 time = 375
* CHECK dout0_31 vdout0_31ck74 = 0 time = 375
* CHECK dout0_0 vdout0_0ck75 = 1.1 time = 380
* CHECK dout0_1 vdout0_1ck75 = 1.1 time = 380
* CHECK dout0_2 vdout0_2ck75 = 0 time = 380
* CHECK dout0_3 vdout0_3ck75 = 0 time = 380
* CHECK dout0_4 vdout0_4ck75 = 0 time = 380
* CHECK dout0_5 vdout0_5ck75 = 1.1 time = 380
* CHECK dout0_6 vdout0_6ck75 = 0 time = 380
* CHECK dout0_7 vdout0_7ck75 = 0 time = 380
* CHECK dout0_8 vdout0_8ck75 = 1.1 time = 380
* CHECK dout0_9 vdout0_9ck75 = 1.1 time = 380
* CHECK dout0_10 vdout0_10ck75 = 0 time = 380
* CHECK dout0_11 vdout0_11ck75 = 1.1 time = 380
* CHECK dout0_12 vdout0_12ck75 = 0 time = 380
* CHECK dout0_13 vdout0_13ck75 = 0 time = 380
* CHECK dout0_14 vdout0_14ck75 = 1.1 time = 380
* CHECK dout0_15 vdout0_15ck75 = 1.1 time = 380
* CHECK dout0_16 vdout0_16ck75 = 0 time = 380
* CHECK dout0_17 vdout0_17ck75 = 1.1 time = 380
* CHECK dout0_18 vdout0_18ck75 = 0 time = 380
* CHECK dout0_19 vdout0_19ck75 = 1.1 time = 380
* CHECK dout0_20 vdout0_20ck75 = 1.1 time = 380
* CHECK dout0_21 vdout0_21ck75 = 1.1 time = 380
* CHECK dout0_22 vdout0_22ck75 = 0 time = 380
* CHECK dout0_23 vdout0_23ck75 = 1.1 time = 380
* CHECK dout0_24 vdout0_24ck75 = 1.1 time = 380
* CHECK dout0_25 vdout0_25ck75 = 0 time = 380
* CHECK dout0_26 vdout0_26ck75 = 0 time = 380
* CHECK dout0_27 vdout0_27ck75 = 0 time = 380
* CHECK dout0_28 vdout0_28ck75 = 0 time = 380
* CHECK dout0_29 vdout0_29ck75 = 0 time = 380
* CHECK dout0_30 vdout0_30ck75 = 1.1 time = 380
* CHECK dout0_31 vdout0_31ck75 = 1.1 time = 380
* CHECK dout0_0 vdout0_0ck77 = 1.1 time = 390
* CHECK dout0_1 vdout0_1ck77 = 1.1 time = 390
* CHECK dout0_2 vdout0_2ck77 = 1.1 time = 390
* CHECK dout0_3 vdout0_3ck77 = 1.1 time = 390
* CHECK dout0_4 vdout0_4ck77 = 0 time = 390
* CHECK dout0_5 vdout0_5ck77 = 0 time = 390
* CHECK dout0_6 vdout0_6ck77 = 0 time = 390
* CHECK dout0_7 vdout0_7ck77 = 0 time = 390
* CHECK dout0_8 vdout0_8ck77 = 0 time = 390
* CHECK dout0_9 vdout0_9ck77 = 0 time = 390
* CHECK dout0_10 vdout0_10ck77 = 1.1 time = 390
* CHECK dout0_11 vdout0_11ck77 = 0 time = 390
* CHECK dout0_12 vdout0_12ck77 = 0 time = 390
* CHECK dout0_13 vdout0_13ck77 = 1.1 time = 390
* CHECK dout0_14 vdout0_14ck77 = 1.1 time = 390
* CHECK dout0_15 vdout0_15ck77 = 1.1 time = 390
* CHECK dout0_16 vdout0_16ck77 = 1.1 time = 390
* CHECK dout0_17 vdout0_17ck77 = 0 time = 390
* CHECK dout0_18 vdout0_18ck77 = 0 time = 390
* CHECK dout0_19 vdout0_19ck77 = 1.1 time = 390
* CHECK dout0_20 vdout0_20ck77 = 0 time = 390
* CHECK dout0_21 vdout0_21ck77 = 1.1 time = 390
* CHECK dout0_22 vdout0_22ck77 = 1.1 time = 390
* CHECK dout0_23 vdout0_23ck77 = 1.1 time = 390
* CHECK dout0_24 vdout0_24ck77 = 1.1 time = 390
* CHECK dout0_25 vdout0_25ck77 = 1.1 time = 390
* CHECK dout0_26 vdout0_26ck77 = 1.1 time = 390
* CHECK dout0_27 vdout0_27ck77 = 0 time = 390
* CHECK dout0_28 vdout0_28ck77 = 1.1 time = 390
* CHECK dout0_29 vdout0_29ck77 = 1.1 time = 390
* CHECK dout0_30 vdout0_30ck77 = 1.1 time = 390
* CHECK dout0_31 vdout0_31ck77 = 0 time = 390
* CHECK dout0_0 vdout0_0ck78 = 0 time = 395
* CHECK dout0_1 vdout0_1ck78 = 0 time = 395
* CHECK dout0_2 vdout0_2ck78 = 1.1 time = 395
* CHECK dout0_3 vdout0_3ck78 = 1.1 time = 395
* CHECK dout0_4 vdout0_4ck78 = 1.1 time = 395
* CHECK dout0_5 vdout0_5ck78 = 0 time = 395
* CHECK dout0_6 vdout0_6ck78 = 1.1 time = 395
* CHECK dout0_7 vdout0_7ck78 = 0 time = 395
* CHECK dout0_8 vdout0_8ck78 = 1.1 time = 395
* CHECK dout0_9 vdout0_9ck78 = 0 time = 395
* CHECK dout0_10 vdout0_10ck78 = 0 time = 395
* CHECK dout0_11 vdout0_11ck78 = 1.1 time = 395
* CHECK dout0_12 vdout0_12ck78 = 1.1 time = 395
* CHECK dout0_13 vdout0_13ck78 = 0 time = 395
* CHECK dout0_14 vdout0_14ck78 = 0 time = 395
* CHECK dout0_15 vdout0_15ck78 = 0 time = 395
* CHECK dout0_16 vdout0_16ck78 = 1.1 time = 395
* CHECK dout0_17 vdout0_17ck78 = 0 time = 395
* CHECK dout0_18 vdout0_18ck78 = 0 time = 395
* CHECK dout0_19 vdout0_19ck78 = 1.1 time = 395
* CHECK dout0_20 vdout0_20ck78 = 1.1 time = 395
* CHECK dout0_21 vdout0_21ck78 = 1.1 time = 395
* CHECK dout0_22 vdout0_22ck78 = 0 time = 395
* CHECK dout0_23 vdout0_23ck78 = 1.1 time = 395
* CHECK dout0_24 vdout0_24ck78 = 1.1 time = 395
* CHECK dout0_25 vdout0_25ck78 = 0 time = 395
* CHECK dout0_26 vdout0_26ck78 = 0 time = 395
* CHECK dout0_27 vdout0_27ck78 = 1.1 time = 395
* CHECK dout0_28 vdout0_28ck78 = 1.1 time = 395
* CHECK dout0_29 vdout0_29ck78 = 0 time = 395
* CHECK dout0_30 vdout0_30ck78 = 0 time = 395
* CHECK dout0_31 vdout0_31ck78 = 1.1 time = 395
* CHECK dout0_0 vdout0_0ck80 = 0 time = 405
* CHECK dout0_1 vdout0_1ck80 = 0 time = 405
* CHECK dout0_2 vdout0_2ck80 = 1.1 time = 405
* CHECK dout0_3 vdout0_3ck80 = 1.1 time = 405
* CHECK dout0_4 vdout0_4ck80 = 0 time = 405
* CHECK dout0_5 vdout0_5ck80 = 0 time = 405
* CHECK dout0_6 vdout0_6ck80 = 1.1 time = 405
* CHECK dout0_7 vdout0_7ck80 = 1.1 time = 405
* CHECK dout0_8 vdout0_8ck80 = 0 time = 405
* CHECK dout0_9 vdout0_9ck80 = 1.1 time = 405
* CHECK dout0_10 vdout0_10ck80 = 0 time = 405
* CHECK dout0_11 vdout0_11ck80 = 1.1 time = 405
* CHECK dout0_12 vdout0_12ck80 = 1.1 time = 405
* CHECK dout0_13 vdout0_13ck80 = 1.1 time = 405
* CHECK dout0_14 vdout0_14ck80 = 0 time = 405
* CHECK dout0_15 vdout0_15ck80 = 0 time = 405
* CHECK dout0_16 vdout0_16ck80 = 1.1 time = 405
* CHECK dout0_17 vdout0_17ck80 = 1.1 time = 405
* CHECK dout0_18 vdout0_18ck80 = 0 time = 405
* CHECK dout0_19 vdout0_19ck80 = 1.1 time = 405
* CHECK dout0_20 vdout0_20ck80 = 1.1 time = 405
* CHECK dout0_21 vdout0_21ck80 = 1.1 time = 405
* CHECK dout0_22 vdout0_22ck80 = 1.1 time = 405
* CHECK dout0_23 vdout0_23ck80 = 0 time = 405
* CHECK dout0_24 vdout0_24ck80 = 1.1 time = 405
* CHECK dout0_25 vdout0_25ck80 = 1.1 time = 405
* CHECK dout0_26 vdout0_26ck80 = 1.1 time = 405
* CHECK dout0_27 vdout0_27ck80 = 1.1 time = 405
* CHECK dout0_28 vdout0_28ck80 = 0 time = 405
* CHECK dout0_29 vdout0_29ck80 = 0 time = 405
* CHECK dout0_30 vdout0_30ck80 = 1.1 time = 405
* CHECK dout0_31 vdout0_31ck80 = 0 time = 405
* CHECK dout0_0 vdout0_0ck82 = 1.1 time = 415
* CHECK dout0_1 vdout0_1ck82 = 1.1 time = 415
* CHECK dout0_2 vdout0_2ck82 = 1.1 time = 415
* CHECK dout0_3 vdout0_3ck82 = 1.1 time = 415
* CHECK dout0_4 vdout0_4ck82 = 0 time = 415
* CHECK dout0_5 vdout0_5ck82 = 0 time = 415
* CHECK dout0_6 vdout0_6ck82 = 1.1 time = 415
* CHECK dout0_7 vdout0_7ck82 = 0 time = 415
* CHECK dout0_8 vdout0_8ck82 = 1.1 time = 415
* CHECK dout0_9 vdout0_9ck82 = 0 time = 415
* CHECK dout0_10 vdout0_10ck82 = 1.1 time = 415
* CHECK dout0_11 vdout0_11ck82 = 1.1 time = 415
* CHECK dout0_12 vdout0_12ck82 = 0 time = 415
* CHECK dout0_13 vdout0_13ck82 = 0 time = 415
* CHECK dout0_14 vdout0_14ck82 = 1.1 time = 415
* CHECK dout0_15 vdout0_15ck82 = 1.1 time = 415
* CHECK dout0_16 vdout0_16ck82 = 0 time = 415
* CHECK dout0_17 vdout0_17ck82 = 1.1 time = 415
* CHECK dout0_18 vdout0_18ck82 = 0 time = 415
* CHECK dout0_19 vdout0_19ck82 = 0 time = 415
* CHECK dout0_20 vdout0_20ck82 = 1.1 time = 415
* CHECK dout0_21 vdout0_21ck82 = 0 time = 415
* CHECK dout0_22 vdout0_22ck82 = 0 time = 415
* CHECK dout0_23 vdout0_23ck82 = 0 time = 415
* CHECK dout0_24 vdout0_24ck82 = 0 time = 415
* CHECK dout0_25 vdout0_25ck82 = 0 time = 415
* CHECK dout0_26 vdout0_26ck82 = 1.1 time = 415
* CHECK dout0_27 vdout0_27ck82 = 1.1 time = 415
* CHECK dout0_28 vdout0_28ck82 = 0 time = 415
* CHECK dout0_29 vdout0_29ck82 = 1.1 time = 415
* CHECK dout0_30 vdout0_30ck82 = 1.1 time = 415
* CHECK dout0_31 vdout0_31ck82 = 1.1 time = 415
* CHECK dout0_0 vdout0_0ck83 = 1.1 time = 420
* CHECK dout0_1 vdout0_1ck83 = 1.1 time = 420
* CHECK dout0_2 vdout0_2ck83 = 1.1 time = 420
* CHECK dout0_3 vdout0_3ck83 = 0 time = 420
* CHECK dout0_4 vdout0_4ck83 = 1.1 time = 420
* CHECK dout0_5 vdout0_5ck83 = 1.1 time = 420
* CHECK dout0_6 vdout0_6ck83 = 1.1 time = 420
* CHECK dout0_7 vdout0_7ck83 = 1.1 time = 420
* CHECK dout0_8 vdout0_8ck83 = 1.1 time = 420
* CHECK dout0_9 vdout0_9ck83 = 1.1 time = 420
* CHECK dout0_10 vdout0_10ck83 = 0 time = 420
* CHECK dout0_11 vdout0_11ck83 = 1.1 time = 420
* CHECK dout0_12 vdout0_12ck83 = 0 time = 420
* CHECK dout0_13 vdout0_13ck83 = 1.1 time = 420
* CHECK dout0_14 vdout0_14ck83 = 1.1 time = 420
* CHECK dout0_15 vdout0_15ck83 = 0 time = 420
* CHECK dout0_16 vdout0_16ck83 = 1.1 time = 420
* CHECK dout0_17 vdout0_17ck83 = 1.1 time = 420
* CHECK dout0_18 vdout0_18ck83 = 1.1 time = 420
* CHECK dout0_19 vdout0_19ck83 = 0 time = 420
* CHECK dout0_20 vdout0_20ck83 = 1.1 time = 420
* CHECK dout0_21 vdout0_21ck83 = 1.1 time = 420
* CHECK dout0_22 vdout0_22ck83 = 1.1 time = 420
* CHECK dout0_23 vdout0_23ck83 = 1.1 time = 420
* CHECK dout0_24 vdout0_24ck83 = 1.1 time = 420
* CHECK dout0_25 vdout0_25ck83 = 1.1 time = 420
* CHECK dout0_26 vdout0_26ck83 = 1.1 time = 420
* CHECK dout0_27 vdout0_27ck83 = 1.1 time = 420
* CHECK dout0_28 vdout0_28ck83 = 1.1 time = 420
* CHECK dout0_29 vdout0_29ck83 = 1.1 time = 420
* CHECK dout0_30 vdout0_30ck83 = 1.1 time = 420
* CHECK dout0_31 vdout0_31ck83 = 1.1 time = 420
* CHECK dout0_0 vdout0_0ck85 = 0 time = 430
* CHECK dout0_1 vdout0_1ck85 = 0 time = 430
* CHECK dout0_2 vdout0_2ck85 = 1.1 time = 430
* CHECK dout0_3 vdout0_3ck85 = 0 time = 430
* CHECK dout0_4 vdout0_4ck85 = 1.1 time = 430
* CHECK dout0_5 vdout0_5ck85 = 1.1 time = 430
* CHECK dout0_6 vdout0_6ck85 = 0 time = 430
* CHECK dout0_7 vdout0_7ck85 = 1.1 time = 430
* CHECK dout0_8 vdout0_8ck85 = 1.1 time = 430
* CHECK dout0_9 vdout0_9ck85 = 0 time = 430
* CHECK dout0_10 vdout0_10ck85 = 0 time = 430
* CHECK dout0_11 vdout0_11ck85 = 0 time = 430
* CHECK dout0_12 vdout0_12ck85 = 0 time = 430
* CHECK dout0_13 vdout0_13ck85 = 0 time = 430
* CHECK dout0_14 vdout0_14ck85 = 1.1 time = 430
* CHECK dout0_15 vdout0_15ck85 = 0 time = 430
* CHECK dout0_16 vdout0_16ck85 = 1.1 time = 430
* CHECK dout0_17 vdout0_17ck85 = 1.1 time = 430
* CHECK dout0_18 vdout0_18ck85 = 0 time = 430
* CHECK dout0_19 vdout0_19ck85 = 1.1 time = 430
* CHECK dout0_20 vdout0_20ck85 = 1.1 time = 430
* CHECK dout0_21 vdout0_21ck85 = 1.1 time = 430
* CHECK dout0_22 vdout0_22ck85 = 1.1 time = 430
* CHECK dout0_23 vdout0_23ck85 = 0 time = 430
* CHECK dout0_24 vdout0_24ck85 = 0 time = 430
* CHECK dout0_25 vdout0_25ck85 = 1.1 time = 430
* CHECK dout0_26 vdout0_26ck85 = 0 time = 430
* CHECK dout0_27 vdout0_27ck85 = 0 time = 430
* CHECK dout0_28 vdout0_28ck85 = 0 time = 430
* CHECK dout0_29 vdout0_29ck85 = 0 time = 430
* CHECK dout0_30 vdout0_30ck85 = 0 time = 430
* CHECK dout0_31 vdout0_31ck85 = 0 time = 430
* CHECK dout0_0 vdout0_0ck86 = 0 time = 435
* CHECK dout0_1 vdout0_1ck86 = 0 time = 435
* CHECK dout0_2 vdout0_2ck86 = 1.1 time = 435
* CHECK dout0_3 vdout0_3ck86 = 1.1 time = 435
* CHECK dout0_4 vdout0_4ck86 = 1.1 time = 435
* CHECK dout0_5 vdout0_5ck86 = 0 time = 435
* CHECK dout0_6 vdout0_6ck86 = 1.1 time = 435
* CHECK dout0_7 vdout0_7ck86 = 0 time = 435
* CHECK dout0_8 vdout0_8ck86 = 1.1 time = 435
* CHECK dout0_9 vdout0_9ck86 = 0 time = 435
* CHECK dout0_10 vdout0_10ck86 = 0 time = 435
* CHECK dout0_11 vdout0_11ck86 = 1.1 time = 435
* CHECK dout0_12 vdout0_12ck86 = 1.1 time = 435
* CHECK dout0_13 vdout0_13ck86 = 0 time = 435
* CHECK dout0_14 vdout0_14ck86 = 0 time = 435
* CHECK dout0_15 vdout0_15ck86 = 0 time = 435
* CHECK dout0_16 vdout0_16ck86 = 1.1 time = 435
* CHECK dout0_17 vdout0_17ck86 = 0 time = 435
* CHECK dout0_18 vdout0_18ck86 = 0 time = 435
* CHECK dout0_19 vdout0_19ck86 = 1.1 time = 435
* CHECK dout0_20 vdout0_20ck86 = 1.1 time = 435
* CHECK dout0_21 vdout0_21ck86 = 1.1 time = 435
* CHECK dout0_22 vdout0_22ck86 = 0 time = 435
* CHECK dout0_23 vdout0_23ck86 = 1.1 time = 435
* CHECK dout0_24 vdout0_24ck86 = 1.1 time = 435
* CHECK dout0_25 vdout0_25ck86 = 0 time = 435
* CHECK dout0_26 vdout0_26ck86 = 0 time = 435
* CHECK dout0_27 vdout0_27ck86 = 1.1 time = 435
* CHECK dout0_28 vdout0_28ck86 = 1.1 time = 435
* CHECK dout0_29 vdout0_29ck86 = 0 time = 435
* CHECK dout0_30 vdout0_30ck86 = 0 time = 435
* CHECK dout0_31 vdout0_31ck86 = 1.1 time = 435
* CHECK dout0_0 vdout0_0ck87 = 1.1 time = 440
* CHECK dout0_1 vdout0_1ck87 = 1.1 time = 440
* CHECK dout0_2 vdout0_2ck87 = 1.1 time = 440
* CHECK dout0_3 vdout0_3ck87 = 1.1 time = 440
* CHECK dout0_4 vdout0_4ck87 = 0 time = 440
* CHECK dout0_5 vdout0_5ck87 = 0 time = 440
* CHECK dout0_6 vdout0_6ck87 = 1.1 time = 440
* CHECK dout0_7 vdout0_7ck87 = 0 time = 440
* CHECK dout0_8 vdout0_8ck87 = 1.1 time = 440
* CHECK dout0_9 vdout0_9ck87 = 0 time = 440
* CHECK dout0_10 vdout0_10ck87 = 1.1 time = 440
* CHECK dout0_11 vdout0_11ck87 = 1.1 time = 440
* CHECK dout0_12 vdout0_12ck87 = 0 time = 440
* CHECK dout0_13 vdout0_13ck87 = 0 time = 440
* CHECK dout0_14 vdout0_14ck87 = 1.1 time = 440
* CHECK dout0_15 vdout0_15ck87 = 1.1 time = 440
* CHECK dout0_16 vdout0_16ck87 = 0 time = 440
* CHECK dout0_17 vdout0_17ck87 = 1.1 time = 440
* CHECK dout0_18 vdout0_18ck87 = 0 time = 440
* CHECK dout0_19 vdout0_19ck87 = 0 time = 440
* CHECK dout0_20 vdout0_20ck87 = 1.1 time = 440
* CHECK dout0_21 vdout0_21ck87 = 0 time = 440
* CHECK dout0_22 vdout0_22ck87 = 0 time = 440
* CHECK dout0_23 vdout0_23ck87 = 0 time = 440
* CHECK dout0_24 vdout0_24ck87 = 0 time = 440
* CHECK dout0_25 vdout0_25ck87 = 0 time = 440
* CHECK dout0_26 vdout0_26ck87 = 1.1 time = 440
* CHECK dout0_27 vdout0_27ck87 = 1.1 time = 440
* CHECK dout0_28 vdout0_28ck87 = 0 time = 440
* CHECK dout0_29 vdout0_29ck87 = 1.1 time = 440
* CHECK dout0_30 vdout0_30ck87 = 1.1 time = 440
* CHECK dout0_31 vdout0_31ck87 = 1.1 time = 440
* CHECK dout0_0 vdout0_0ck89 = 1.1 time = 450
* CHECK dout0_1 vdout0_1ck89 = 1.1 time = 450
* CHECK dout0_2 vdout0_2ck89 = 1.1 time = 450
* CHECK dout0_3 vdout0_3ck89 = 1.1 time = 450
* CHECK dout0_4 vdout0_4ck89 = 0 time = 450
* CHECK dout0_5 vdout0_5ck89 = 0 time = 450
* CHECK dout0_6 vdout0_6ck89 = 1.1 time = 450
* CHECK dout0_7 vdout0_7ck89 = 0 time = 450
* CHECK dout0_8 vdout0_8ck89 = 1.1 time = 450
* CHECK dout0_9 vdout0_9ck89 = 0 time = 450
* CHECK dout0_10 vdout0_10ck89 = 1.1 time = 450
* CHECK dout0_11 vdout0_11ck89 = 1.1 time = 450
* CHECK dout0_12 vdout0_12ck89 = 0 time = 450
* CHECK dout0_13 vdout0_13ck89 = 0 time = 450
* CHECK dout0_14 vdout0_14ck89 = 1.1 time = 450
* CHECK dout0_15 vdout0_15ck89 = 1.1 time = 450
* CHECK dout0_16 vdout0_16ck89 = 0 time = 450
* CHECK dout0_17 vdout0_17ck89 = 1.1 time = 450
* CHECK dout0_18 vdout0_18ck89 = 0 time = 450
* CHECK dout0_19 vdout0_19ck89 = 0 time = 450
* CHECK dout0_20 vdout0_20ck89 = 1.1 time = 450
* CHECK dout0_21 vdout0_21ck89 = 0 time = 450
* CHECK dout0_22 vdout0_22ck89 = 0 time = 450
* CHECK dout0_23 vdout0_23ck89 = 0 time = 450
* CHECK dout0_24 vdout0_24ck89 = 0 time = 450
* CHECK dout0_25 vdout0_25ck89 = 0 time = 450
* CHECK dout0_26 vdout0_26ck89 = 1.1 time = 450
* CHECK dout0_27 vdout0_27ck89 = 1.1 time = 450
* CHECK dout0_28 vdout0_28ck89 = 0 time = 450
* CHECK dout0_29 vdout0_29ck89 = 1.1 time = 450
* CHECK dout0_30 vdout0_30ck89 = 1.1 time = 450
* CHECK dout0_31 vdout0_31ck89 = 1.1 time = 450
* CHECK dout0_0 vdout0_0ck90 = 1.1 time = 455
* CHECK dout0_1 vdout0_1ck90 = 1.1 time = 455
* CHECK dout0_2 vdout0_2ck90 = 1.1 time = 455
* CHECK dout0_3 vdout0_3ck90 = 1.1 time = 455
* CHECK dout0_4 vdout0_4ck90 = 0 time = 455
* CHECK dout0_5 vdout0_5ck90 = 0 time = 455
* CHECK dout0_6 vdout0_6ck90 = 1.1 time = 455
* CHECK dout0_7 vdout0_7ck90 = 0 time = 455
* CHECK dout0_8 vdout0_8ck90 = 1.1 time = 455
* CHECK dout0_9 vdout0_9ck90 = 0 time = 455
* CHECK dout0_10 vdout0_10ck90 = 1.1 time = 455
* CHECK dout0_11 vdout0_11ck90 = 1.1 time = 455
* CHECK dout0_12 vdout0_12ck90 = 0 time = 455
* CHECK dout0_13 vdout0_13ck90 = 0 time = 455
* CHECK dout0_14 vdout0_14ck90 = 1.1 time = 455
* CHECK dout0_15 vdout0_15ck90 = 1.1 time = 455
* CHECK dout0_16 vdout0_16ck90 = 0 time = 455
* CHECK dout0_17 vdout0_17ck90 = 1.1 time = 455
* CHECK dout0_18 vdout0_18ck90 = 0 time = 455
* CHECK dout0_19 vdout0_19ck90 = 0 time = 455
* CHECK dout0_20 vdout0_20ck90 = 1.1 time = 455
* CHECK dout0_21 vdout0_21ck90 = 0 time = 455
* CHECK dout0_22 vdout0_22ck90 = 0 time = 455
* CHECK dout0_23 vdout0_23ck90 = 0 time = 455
* CHECK dout0_24 vdout0_24ck90 = 0 time = 455
* CHECK dout0_25 vdout0_25ck90 = 0 time = 455
* CHECK dout0_26 vdout0_26ck90 = 1.1 time = 455
* CHECK dout0_27 vdout0_27ck90 = 1.1 time = 455
* CHECK dout0_28 vdout0_28ck90 = 0 time = 455
* CHECK dout0_29 vdout0_29ck90 = 1.1 time = 455
* CHECK dout0_30 vdout0_30ck90 = 1.1 time = 455
* CHECK dout0_31 vdout0_31ck90 = 1.1 time = 455
* CHECK dout0_0 vdout0_0ck91 = 0 time = 460
* CHECK dout0_1 vdout0_1ck91 = 0 time = 460
* CHECK dout0_2 vdout0_2ck91 = 1.1 time = 460
* CHECK dout0_3 vdout0_3ck91 = 1.1 time = 460
* CHECK dout0_4 vdout0_4ck91 = 1.1 time = 460
* CHECK dout0_5 vdout0_5ck91 = 0 time = 460
* CHECK dout0_6 vdout0_6ck91 = 1.1 time = 460
* CHECK dout0_7 vdout0_7ck91 = 0 time = 460
* CHECK dout0_8 vdout0_8ck91 = 1.1 time = 460
* CHECK dout0_9 vdout0_9ck91 = 0 time = 460
* CHECK dout0_10 vdout0_10ck91 = 0 time = 460
* CHECK dout0_11 vdout0_11ck91 = 1.1 time = 460
* CHECK dout0_12 vdout0_12ck91 = 1.1 time = 460
* CHECK dout0_13 vdout0_13ck91 = 0 time = 460
* CHECK dout0_14 vdout0_14ck91 = 0 time = 460
* CHECK dout0_15 vdout0_15ck91 = 0 time = 460
* CHECK dout0_16 vdout0_16ck91 = 1.1 time = 460
* CHECK dout0_17 vdout0_17ck91 = 0 time = 460
* CHECK dout0_18 vdout0_18ck91 = 0 time = 460
* CHECK dout0_19 vdout0_19ck91 = 1.1 time = 460
* CHECK dout0_20 vdout0_20ck91 = 1.1 time = 460
* CHECK dout0_21 vdout0_21ck91 = 1.1 time = 460
* CHECK dout0_22 vdout0_22ck91 = 0 time = 460
* CHECK dout0_23 vdout0_23ck91 = 1.1 time = 460
* CHECK dout0_24 vdout0_24ck91 = 1.1 time = 460
* CHECK dout0_25 vdout0_25ck91 = 0 time = 460
* CHECK dout0_26 vdout0_26ck91 = 0 time = 460
* CHECK dout0_27 vdout0_27ck91 = 1.1 time = 460
* CHECK dout0_28 vdout0_28ck91 = 1.1 time = 460
* CHECK dout0_29 vdout0_29ck91 = 0 time = 460
* CHECK dout0_30 vdout0_30ck91 = 0 time = 460
* CHECK dout0_31 vdout0_31ck91 = 1.1 time = 460
* CHECK dout0_0 vdout0_0ck93 = 0 time = 470
* CHECK dout0_1 vdout0_1ck93 = 0 time = 470
* CHECK dout0_2 vdout0_2ck93 = 1.1 time = 470
* CHECK dout0_3 vdout0_3ck93 = 0 time = 470
* CHECK dout0_4 vdout0_4ck93 = 1.1 time = 470
* CHECK dout0_5 vdout0_5ck93 = 1.1 time = 470
* CHECK dout0_6 vdout0_6ck93 = 0 time = 470
* CHECK dout0_7 vdout0_7ck93 = 1.1 time = 470
* CHECK dout0_8 vdout0_8ck93 = 1.1 time = 470
* CHECK dout0_9 vdout0_9ck93 = 0 time = 470
* CHECK dout0_10 vdout0_10ck93 = 0 time = 470
* CHECK dout0_11 vdout0_11ck93 = 0 time = 470
* CHECK dout0_12 vdout0_12ck93 = 0 time = 470
* CHECK dout0_13 vdout0_13ck93 = 0 time = 470
* CHECK dout0_14 vdout0_14ck93 = 1.1 time = 470
* CHECK dout0_15 vdout0_15ck93 = 0 time = 470
* CHECK dout0_16 vdout0_16ck93 = 1.1 time = 470
* CHECK dout0_17 vdout0_17ck93 = 1.1 time = 470
* CHECK dout0_18 vdout0_18ck93 = 0 time = 470
* CHECK dout0_19 vdout0_19ck93 = 1.1 time = 470
* CHECK dout0_20 vdout0_20ck93 = 1.1 time = 470
* CHECK dout0_21 vdout0_21ck93 = 1.1 time = 470
* CHECK dout0_22 vdout0_22ck93 = 1.1 time = 470
* CHECK dout0_23 vdout0_23ck93 = 0 time = 470
* CHECK dout0_24 vdout0_24ck93 = 0 time = 470
* CHECK dout0_25 vdout0_25ck93 = 1.1 time = 470
* CHECK dout0_26 vdout0_26ck93 = 0 time = 470
* CHECK dout0_27 vdout0_27ck93 = 0 time = 470
* CHECK dout0_28 vdout0_28ck93 = 0 time = 470
* CHECK dout0_29 vdout0_29ck93 = 0 time = 470
* CHECK dout0_30 vdout0_30ck93 = 0 time = 470
* CHECK dout0_31 vdout0_31ck93 = 0 time = 470
* CHECK dout0_0 vdout0_0ck96 = 0 time = 485
* CHECK dout0_1 vdout0_1ck96 = 0 time = 485
* CHECK dout0_2 vdout0_2ck96 = 1.1 time = 485
* CHECK dout0_3 vdout0_3ck96 = 1.1 time = 485
* CHECK dout0_4 vdout0_4ck96 = 0 time = 485
* CHECK dout0_5 vdout0_5ck96 = 0 time = 485
* CHECK dout0_6 vdout0_6ck96 = 1.1 time = 485
* CHECK dout0_7 vdout0_7ck96 = 0 time = 485
* CHECK dout0_8 vdout0_8ck96 = 0 time = 485
* CHECK dout0_9 vdout0_9ck96 = 1.1 time = 485
* CHECK dout0_10 vdout0_10ck96 = 1.1 time = 485
* CHECK dout0_11 vdout0_11ck96 = 0 time = 485
* CHECK dout0_12 vdout0_12ck96 = 0 time = 485
* CHECK dout0_13 vdout0_13ck96 = 1.1 time = 485
* CHECK dout0_14 vdout0_14ck96 = 0 time = 485
* CHECK dout0_15 vdout0_15ck96 = 0 time = 485
* CHECK dout0_16 vdout0_16ck96 = 1.1 time = 485
* CHECK dout0_17 vdout0_17ck96 = 0 time = 485
* CHECK dout0_18 vdout0_18ck96 = 0 time = 485
* CHECK dout0_19 vdout0_19ck96 = 1.1 time = 485
* CHECK dout0_20 vdout0_20ck96 = 0 time = 485
* CHECK dout0_21 vdout0_21ck96 = 0 time = 485
* CHECK dout0_22 vdout0_22ck96 = 0 time = 485
* CHECK dout0_23 vdout0_23ck96 = 1.1 time = 485
* CHECK dout0_24 vdout0_24ck96 = 0 time = 485
* CHECK dout0_25 vdout0_25ck96 = 0 time = 485
* CHECK dout0_26 vdout0_26ck96 = 1.1 time = 485
* CHECK dout0_27 vdout0_27ck96 = 0 time = 485
* CHECK dout0_28 vdout0_28ck96 = 0 time = 485
* CHECK dout0_29 vdout0_29ck96 = 0 time = 485
* CHECK dout0_30 vdout0_30ck96 = 1.1 time = 485
* CHECK dout0_31 vdout0_31ck96 = 1.1 time = 485
* CHECK dout0_0 vdout0_0ck98 = 1.1 time = 495
* CHECK dout0_1 vdout0_1ck98 = 1.1 time = 495
* CHECK dout0_2 vdout0_2ck98 = 1.1 time = 495
* CHECK dout0_3 vdout0_3ck98 = 0 time = 495
* CHECK dout0_4 vdout0_4ck98 = 1.1 time = 495
* CHECK dout0_5 vdout0_5ck98 = 1.1 time = 495
* CHECK dout0_6 vdout0_6ck98 = 1.1 time = 495
* CHECK dout0_7 vdout0_7ck98 = 1.1 time = 495
* CHECK dout0_8 vdout0_8ck98 = 1.1 time = 495
* CHECK dout0_9 vdout0_9ck98 = 1.1 time = 495
* CHECK dout0_10 vdout0_10ck98 = 0 time = 495
* CHECK dout0_11 vdout0_11ck98 = 1.1 time = 495
* CHECK dout0_12 vdout0_12ck98 = 0 time = 495
* CHECK dout0_13 vdout0_13ck98 = 1.1 time = 495
* CHECK dout0_14 vdout0_14ck98 = 1.1 time = 495
* CHECK dout0_15 vdout0_15ck98 = 0 time = 495
* CHECK dout0_16 vdout0_16ck98 = 1.1 time = 495
* CHECK dout0_17 vdout0_17ck98 = 1.1 time = 495
* CHECK dout0_18 vdout0_18ck98 = 1.1 time = 495
* CHECK dout0_19 vdout0_19ck98 = 0 time = 495
* CHECK dout0_20 vdout0_20ck98 = 1.1 time = 495
* CHECK dout0_21 vdout0_21ck98 = 1.1 time = 495
* CHECK dout0_22 vdout0_22ck98 = 1.1 time = 495
* CHECK dout0_23 vdout0_23ck98 = 1.1 time = 495
* CHECK dout0_24 vdout0_24ck98 = 1.1 time = 495
* CHECK dout0_25 vdout0_25ck98 = 1.1 time = 495
* CHECK dout0_26 vdout0_26ck98 = 1.1 time = 495
* CHECK dout0_27 vdout0_27ck98 = 1.1 time = 495
* CHECK dout0_28 vdout0_28ck98 = 1.1 time = 495
* CHECK dout0_29 vdout0_29ck98 = 1.1 time = 495
* CHECK dout0_30 vdout0_30ck98 = 1.1 time = 495
* CHECK dout0_31 vdout0_31ck98 = 1.1 time = 495
* CHECK dout0_0 vdout0_0ck101 = 0 time = 510
* CHECK dout0_1 vdout0_1ck101 = 0 time = 510
* CHECK dout0_2 vdout0_2ck101 = 1.1 time = 510
* CHECK dout0_3 vdout0_3ck101 = 0 time = 510
* CHECK dout0_4 vdout0_4ck101 = 1.1 time = 510
* CHECK dout0_5 vdout0_5ck101 = 1.1 time = 510
* CHECK dout0_6 vdout0_6ck101 = 0 time = 510
* CHECK dout0_7 vdout0_7ck101 = 1.1 time = 510
* CHECK dout0_8 vdout0_8ck101 = 1.1 time = 510
* CHECK dout0_9 vdout0_9ck101 = 0 time = 510
* CHECK dout0_10 vdout0_10ck101 = 0 time = 510
* CHECK dout0_11 vdout0_11ck101 = 0 time = 510
* CHECK dout0_12 vdout0_12ck101 = 0 time = 510
* CHECK dout0_13 vdout0_13ck101 = 0 time = 510
* CHECK dout0_14 vdout0_14ck101 = 1.1 time = 510
* CHECK dout0_15 vdout0_15ck101 = 0 time = 510
* CHECK dout0_16 vdout0_16ck101 = 1.1 time = 510
* CHECK dout0_17 vdout0_17ck101 = 1.1 time = 510
* CHECK dout0_18 vdout0_18ck101 = 0 time = 510
* CHECK dout0_19 vdout0_19ck101 = 1.1 time = 510
* CHECK dout0_20 vdout0_20ck101 = 1.1 time = 510
* CHECK dout0_21 vdout0_21ck101 = 1.1 time = 510
* CHECK dout0_22 vdout0_22ck101 = 1.1 time = 510
* CHECK dout0_23 vdout0_23ck101 = 0 time = 510
* CHECK dout0_24 vdout0_24ck101 = 0 time = 510
* CHECK dout0_25 vdout0_25ck101 = 1.1 time = 510
* CHECK dout0_26 vdout0_26ck101 = 0 time = 510
* CHECK dout0_27 vdout0_27ck101 = 0 time = 510
* CHECK dout0_28 vdout0_28ck101 = 0 time = 510
* CHECK dout0_29 vdout0_29ck101 = 0 time = 510
* CHECK dout0_30 vdout0_30ck101 = 0 time = 510
* CHECK dout0_31 vdout0_31ck101 = 0 time = 510
* CHECK dout0_0 vdout0_0ck102 = 1.1 time = 515
* CHECK dout0_1 vdout0_1ck102 = 0 time = 515
* CHECK dout0_2 vdout0_2ck102 = 0 time = 515
* CHECK dout0_3 vdout0_3ck102 = 0 time = 515
* CHECK dout0_4 vdout0_4ck102 = 0 time = 515
* CHECK dout0_5 vdout0_5ck102 = 1.1 time = 515
* CHECK dout0_6 vdout0_6ck102 = 1.1 time = 515
* CHECK dout0_7 vdout0_7ck102 = 0 time = 515
* CHECK dout0_8 vdout0_8ck102 = 1.1 time = 515
* CHECK dout0_9 vdout0_9ck102 = 0 time = 515
* CHECK dout0_10 vdout0_10ck102 = 1.1 time = 515
* CHECK dout0_11 vdout0_11ck102 = 1.1 time = 515
* CHECK dout0_12 vdout0_12ck102 = 0 time = 515
* CHECK dout0_13 vdout0_13ck102 = 1.1 time = 515
* CHECK dout0_14 vdout0_14ck102 = 1.1 time = 515
* CHECK dout0_15 vdout0_15ck102 = 1.1 time = 515
* CHECK dout0_16 vdout0_16ck102 = 1.1 time = 515
* CHECK dout0_17 vdout0_17ck102 = 1.1 time = 515
* CHECK dout0_18 vdout0_18ck102 = 1.1 time = 515
* CHECK dout0_19 vdout0_19ck102 = 1.1 time = 515
* CHECK dout0_20 vdout0_20ck102 = 1.1 time = 515
* CHECK dout0_21 vdout0_21ck102 = 0 time = 515
* CHECK dout0_22 vdout0_22ck102 = 0 time = 515
* CHECK dout0_23 vdout0_23ck102 = 0 time = 515
* CHECK dout0_24 vdout0_24ck102 = 1.1 time = 515
* CHECK dout0_25 vdout0_25ck102 = 1.1 time = 515
* CHECK dout0_26 vdout0_26ck102 = 0 time = 515
* CHECK dout0_27 vdout0_27ck102 = 0 time = 515
* CHECK dout0_28 vdout0_28ck102 = 1.1 time = 515
* CHECK dout0_29 vdout0_29ck102 = 1.1 time = 515
* CHECK dout0_30 vdout0_30ck102 = 0 time = 515
* CHECK dout0_31 vdout0_31ck102 = 1.1 time = 515
* CHECK dout0_0 vdout0_0ck106 = 1.1 time = 535
* CHECK dout0_1 vdout0_1ck106 = 0 time = 535
* CHECK dout0_2 vdout0_2ck106 = 0 time = 535
* CHECK dout0_3 vdout0_3ck106 = 0 time = 535
* CHECK dout0_4 vdout0_4ck106 = 0 time = 535
* CHECK dout0_5 vdout0_5ck106 = 1.1 time = 535
* CHECK dout0_6 vdout0_6ck106 = 1.1 time = 535
* CHECK dout0_7 vdout0_7ck106 = 0 time = 535
* CHECK dout0_8 vdout0_8ck106 = 1.1 time = 535
* CHECK dout0_9 vdout0_9ck106 = 0 time = 535
* CHECK dout0_10 vdout0_10ck106 = 1.1 time = 535
* CHECK dout0_11 vdout0_11ck106 = 1.1 time = 535
* CHECK dout0_12 vdout0_12ck106 = 0 time = 535
* CHECK dout0_13 vdout0_13ck106 = 1.1 time = 535
* CHECK dout0_14 vdout0_14ck106 = 1.1 time = 535
* CHECK dout0_15 vdout0_15ck106 = 1.1 time = 535
* CHECK dout0_16 vdout0_16ck106 = 1.1 time = 535
* CHECK dout0_17 vdout0_17ck106 = 1.1 time = 535
* CHECK dout0_18 vdout0_18ck106 = 1.1 time = 535
* CHECK dout0_19 vdout0_19ck106 = 1.1 time = 535
* CHECK dout0_20 vdout0_20ck106 = 1.1 time = 535
* CHECK dout0_21 vdout0_21ck106 = 0 time = 535
* CHECK dout0_22 vdout0_22ck106 = 0 time = 535
* CHECK dout0_23 vdout0_23ck106 = 0 time = 535
* CHECK dout0_24 vdout0_24ck106 = 1.1 time = 535
* CHECK dout0_25 vdout0_25ck106 = 1.1 time = 535
* CHECK dout0_26 vdout0_26ck106 = 0 time = 535
* CHECK dout0_27 vdout0_27ck106 = 0 time = 535
* CHECK dout0_28 vdout0_28ck106 = 1.1 time = 535
* CHECK dout0_29 vdout0_29ck106 = 1.1 time = 535
* CHECK dout0_30 vdout0_30ck106 = 0 time = 535
* CHECK dout0_31 vdout0_31ck106 = 1.1 time = 535
* CHECK dout0_0 vdout0_0ck108 = 1.1 time = 545
* CHECK dout0_1 vdout0_1ck108 = 1.1 time = 545
* CHECK dout0_2 vdout0_2ck108 = 0 time = 545
* CHECK dout0_3 vdout0_3ck108 = 1.1 time = 545
* CHECK dout0_4 vdout0_4ck108 = 1.1 time = 545
* CHECK dout0_5 vdout0_5ck108 = 1.1 time = 545
* CHECK dout0_6 vdout0_6ck108 = 0 time = 545
* CHECK dout0_7 vdout0_7ck108 = 0 time = 545
* CHECK dout0_8 vdout0_8ck108 = 0 time = 545
* CHECK dout0_9 vdout0_9ck108 = 1.1 time = 545
* CHECK dout0_10 vdout0_10ck108 = 0 time = 545
* CHECK dout0_11 vdout0_11ck108 = 0 time = 545
* CHECK dout0_12 vdout0_12ck108 = 1.1 time = 545
* CHECK dout0_13 vdout0_13ck108 = 0 time = 545
* CHECK dout0_14 vdout0_14ck108 = 1.1 time = 545
* CHECK dout0_15 vdout0_15ck108 = 0 time = 545
* CHECK dout0_16 vdout0_16ck108 = 0 time = 545
* CHECK dout0_17 vdout0_17ck108 = 1.1 time = 545
* CHECK dout0_18 vdout0_18ck108 = 1.1 time = 545
* CHECK dout0_19 vdout0_19ck108 = 1.1 time = 545
* CHECK dout0_20 vdout0_20ck108 = 1.1 time = 545
* CHECK dout0_21 vdout0_21ck108 = 1.1 time = 545
* CHECK dout0_22 vdout0_22ck108 = 1.1 time = 545
* CHECK dout0_23 vdout0_23ck108 = 1.1 time = 545
* CHECK dout0_24 vdout0_24ck108 = 0 time = 545
* CHECK dout0_25 vdout0_25ck108 = 0 time = 545
* CHECK dout0_26 vdout0_26ck108 = 0 time = 545
* CHECK dout0_27 vdout0_27ck108 = 0 time = 545
* CHECK dout0_28 vdout0_28ck108 = 0 time = 545
* CHECK dout0_29 vdout0_29ck108 = 1.1 time = 545
* CHECK dout0_30 vdout0_30ck108 = 0 time = 545
* CHECK dout0_31 vdout0_31ck108 = 1.1 time = 545
* CHECK dout0_0 vdout0_0ck109 = 0 time = 550
* CHECK dout0_1 vdout0_1ck109 = 0 time = 550
* CHECK dout0_2 vdout0_2ck109 = 1.1 time = 550
* CHECK dout0_3 vdout0_3ck109 = 1.1 time = 550
* CHECK dout0_4 vdout0_4ck109 = 0 time = 550
* CHECK dout0_5 vdout0_5ck109 = 0 time = 550
* CHECK dout0_6 vdout0_6ck109 = 1.1 time = 550
* CHECK dout0_7 vdout0_7ck109 = 0 time = 550
* CHECK dout0_8 vdout0_8ck109 = 0 time = 550
* CHECK dout0_9 vdout0_9ck109 = 1.1 time = 550
* CHECK dout0_10 vdout0_10ck109 = 1.1 time = 550
* CHECK dout0_11 vdout0_11ck109 = 0 time = 550
* CHECK dout0_12 vdout0_12ck109 = 0 time = 550
* CHECK dout0_13 vdout0_13ck109 = 1.1 time = 550
* CHECK dout0_14 vdout0_14ck109 = 0 time = 550
* CHECK dout0_15 vdout0_15ck109 = 0 time = 550
* CHECK dout0_16 vdout0_16ck109 = 1.1 time = 550
* CHECK dout0_17 vdout0_17ck109 = 0 time = 550
* CHECK dout0_18 vdout0_18ck109 = 0 time = 550
* CHECK dout0_19 vdout0_19ck109 = 1.1 time = 550
* CHECK dout0_20 vdout0_20ck109 = 0 time = 550
* CHECK dout0_21 vdout0_21ck109 = 0 time = 550
* CHECK dout0_22 vdout0_22ck109 = 0 time = 550
* CHECK dout0_23 vdout0_23ck109 = 1.1 time = 550
* CHECK dout0_24 vdout0_24ck109 = 0 time = 550
* CHECK dout0_25 vdout0_25ck109 = 0 time = 550
* CHECK dout0_26 vdout0_26ck109 = 1.1 time = 550
* CHECK dout0_27 vdout0_27ck109 = 0 time = 550
* CHECK dout0_28 vdout0_28ck109 = 0 time = 550
* CHECK dout0_29 vdout0_29ck109 = 0 time = 550
* CHECK dout0_30 vdout0_30ck109 = 1.1 time = 550
* CHECK dout0_31 vdout0_31ck109 = 1.1 time = 550
* CHECK dout0_0 vdout0_0ck110 = 0 time = 555
* CHECK dout0_1 vdout0_1ck110 = 0 time = 555
* CHECK dout0_2 vdout0_2ck110 = 0 time = 555
* CHECK dout0_3 vdout0_3ck110 = 0 time = 555
* CHECK dout0_4 vdout0_4ck110 = 1.1 time = 555
* CHECK dout0_5 vdout0_5ck110 = 1.1 time = 555
* CHECK dout0_6 vdout0_6ck110 = 1.1 time = 555
* CHECK dout0_7 vdout0_7ck110 = 0 time = 555
* CHECK dout0_8 vdout0_8ck110 = 1.1 time = 555
* CHECK dout0_9 vdout0_9ck110 = 0 time = 555
* CHECK dout0_10 vdout0_10ck110 = 1.1 time = 555
* CHECK dout0_11 vdout0_11ck110 = 0 time = 555
* CHECK dout0_12 vdout0_12ck110 = 0 time = 555
* CHECK dout0_13 vdout0_13ck110 = 1.1 time = 555
* CHECK dout0_14 vdout0_14ck110 = 1.1 time = 555
* CHECK dout0_15 vdout0_15ck110 = 0 time = 555
* CHECK dout0_16 vdout0_16ck110 = 1.1 time = 555
* CHECK dout0_17 vdout0_17ck110 = 0 time = 555
* CHECK dout0_18 vdout0_18ck110 = 0 time = 555
* CHECK dout0_19 vdout0_19ck110 = 0 time = 555
* CHECK dout0_20 vdout0_20ck110 = 0 time = 555
* CHECK dout0_21 vdout0_21ck110 = 1.1 time = 555
* CHECK dout0_22 vdout0_22ck110 = 1.1 time = 555
* CHECK dout0_23 vdout0_23ck110 = 0 time = 555
* CHECK dout0_24 vdout0_24ck110 = 0 time = 555
* CHECK dout0_25 vdout0_25ck110 = 0 time = 555
* CHECK dout0_26 vdout0_26ck110 = 0 time = 555
* CHECK dout0_27 vdout0_27ck110 = 1.1 time = 555
* CHECK dout0_28 vdout0_28ck110 = 0 time = 555
* CHECK dout0_29 vdout0_29ck110 = 1.1 time = 555
* CHECK dout0_30 vdout0_30ck110 = 0 time = 555
* CHECK dout0_31 vdout0_31ck110 = 0 time = 555
* CHECK dout0_0 vdout0_0ck111 = 1.1 time = 560
* CHECK dout0_1 vdout0_1ck111 = 1.1 time = 560
* CHECK dout0_2 vdout0_2ck111 = 1.1 time = 560
* CHECK dout0_3 vdout0_3ck111 = 1.1 time = 560
* CHECK dout0_4 vdout0_4ck111 = 0 time = 560
* CHECK dout0_5 vdout0_5ck111 = 0 time = 560
* CHECK dout0_6 vdout0_6ck111 = 1.1 time = 560
* CHECK dout0_7 vdout0_7ck111 = 0 time = 560
* CHECK dout0_8 vdout0_8ck111 = 1.1 time = 560
* CHECK dout0_9 vdout0_9ck111 = 0 time = 560
* CHECK dout0_10 vdout0_10ck111 = 1.1 time = 560
* CHECK dout0_11 vdout0_11ck111 = 1.1 time = 560
* CHECK dout0_12 vdout0_12ck111 = 0 time = 560
* CHECK dout0_13 vdout0_13ck111 = 0 time = 560
* CHECK dout0_14 vdout0_14ck111 = 1.1 time = 560
* CHECK dout0_15 vdout0_15ck111 = 1.1 time = 560
* CHECK dout0_16 vdout0_16ck111 = 0 time = 560
* CHECK dout0_17 vdout0_17ck111 = 1.1 time = 560
* CHECK dout0_18 vdout0_18ck111 = 0 time = 560
* CHECK dout0_19 vdout0_19ck111 = 0 time = 560
* CHECK dout0_20 vdout0_20ck111 = 1.1 time = 560
* CHECK dout0_21 vdout0_21ck111 = 0 time = 560
* CHECK dout0_22 vdout0_22ck111 = 0 time = 560
* CHECK dout0_23 vdout0_23ck111 = 0 time = 560
* CHECK dout0_24 vdout0_24ck111 = 0 time = 560
* CHECK dout0_25 vdout0_25ck111 = 0 time = 560
* CHECK dout0_26 vdout0_26ck111 = 1.1 time = 560
* CHECK dout0_27 vdout0_27ck111 = 1.1 time = 560
* CHECK dout0_28 vdout0_28ck111 = 0 time = 560
* CHECK dout0_29 vdout0_29ck111 = 1.1 time = 560
* CHECK dout0_30 vdout0_30ck111 = 1.1 time = 560
* CHECK dout0_31 vdout0_31ck111 = 1.1 time = 560
* CHECK dout0_0 vdout0_0ck112 = 1.1 time = 565
* CHECK dout0_1 vdout0_1ck112 = 1.1 time = 565
* CHECK dout0_2 vdout0_2ck112 = 0 time = 565
* CHECK dout0_3 vdout0_3ck112 = 1.1 time = 565
* CHECK dout0_4 vdout0_4ck112 = 1.1 time = 565
* CHECK dout0_5 vdout0_5ck112 = 1.1 time = 565
* CHECK dout0_6 vdout0_6ck112 = 0 time = 565
* CHECK dout0_7 vdout0_7ck112 = 0 time = 565
* CHECK dout0_8 vdout0_8ck112 = 0 time = 565
* CHECK dout0_9 vdout0_9ck112 = 1.1 time = 565
* CHECK dout0_10 vdout0_10ck112 = 0 time = 565
* CHECK dout0_11 vdout0_11ck112 = 0 time = 565
* CHECK dout0_12 vdout0_12ck112 = 1.1 time = 565
* CHECK dout0_13 vdout0_13ck112 = 0 time = 565
* CHECK dout0_14 vdout0_14ck112 = 1.1 time = 565
* CHECK dout0_15 vdout0_15ck112 = 0 time = 565
* CHECK dout0_16 vdout0_16ck112 = 0 time = 565
* CHECK dout0_17 vdout0_17ck112 = 1.1 time = 565
* CHECK dout0_18 vdout0_18ck112 = 1.1 time = 565
* CHECK dout0_19 vdout0_19ck112 = 1.1 time = 565
* CHECK dout0_20 vdout0_20ck112 = 1.1 time = 565
* CHECK dout0_21 vdout0_21ck112 = 1.1 time = 565
* CHECK dout0_22 vdout0_22ck112 = 1.1 time = 565
* CHECK dout0_23 vdout0_23ck112 = 1.1 time = 565
* CHECK dout0_24 vdout0_24ck112 = 0 time = 565
* CHECK dout0_25 vdout0_25ck112 = 0 time = 565
* CHECK dout0_26 vdout0_26ck112 = 0 time = 565
* CHECK dout0_27 vdout0_27ck112 = 0 time = 565
* CHECK dout0_28 vdout0_28ck112 = 0 time = 565
* CHECK dout0_29 vdout0_29ck112 = 1.1 time = 565
* CHECK dout0_30 vdout0_30ck112 = 0 time = 565
* CHECK dout0_31 vdout0_31ck112 = 1.1 time = 565
* CHECK dout0_0 vdout0_0ck113 = 0 time = 570
* CHECK dout0_1 vdout0_1ck113 = 0 time = 570
* CHECK dout0_2 vdout0_2ck113 = 0 time = 570
* CHECK dout0_3 vdout0_3ck113 = 0 time = 570
* CHECK dout0_4 vdout0_4ck113 = 0 time = 570
* CHECK dout0_5 vdout0_5ck113 = 0 time = 570
* CHECK dout0_6 vdout0_6ck113 = 0 time = 570
* CHECK dout0_7 vdout0_7ck113 = 0 time = 570
* CHECK dout0_8 vdout0_8ck113 = 1.1 time = 570
* CHECK dout0_9 vdout0_9ck113 = 1.1 time = 570
* CHECK dout0_10 vdout0_10ck113 = 0 time = 570
* CHECK dout0_11 vdout0_11ck113 = 0 time = 570
* CHECK dout0_12 vdout0_12ck113 = 1.1 time = 570
* CHECK dout0_13 vdout0_13ck113 = 1.1 time = 570
* CHECK dout0_14 vdout0_14ck113 = 0 time = 570
* CHECK dout0_15 vdout0_15ck113 = 0 time = 570
* CHECK dout0_16 vdout0_16ck113 = 1.1 time = 570
* CHECK dout0_17 vdout0_17ck113 = 1.1 time = 570
* CHECK dout0_18 vdout0_18ck113 = 1.1 time = 570
* CHECK dout0_19 vdout0_19ck113 = 0 time = 570
* CHECK dout0_20 vdout0_20ck113 = 0 time = 570
* CHECK dout0_21 vdout0_21ck113 = 1.1 time = 570
* CHECK dout0_22 vdout0_22ck113 = 0 time = 570
* CHECK dout0_23 vdout0_23ck113 = 1.1 time = 570
* CHECK dout0_24 vdout0_24ck113 = 0 time = 570
* CHECK dout0_25 vdout0_25ck113 = 0 time = 570
* CHECK dout0_26 vdout0_26ck113 = 0 time = 570
* CHECK dout0_27 vdout0_27ck113 = 1.1 time = 570
* CHECK dout0_28 vdout0_28ck113 = 1.1 time = 570
* CHECK dout0_29 vdout0_29ck113 = 1.1 time = 570
* CHECK dout0_30 vdout0_30ck113 = 1.1 time = 570
* CHECK dout0_31 vdout0_31ck113 = 0 time = 570
* CHECK dout0_0 vdout0_0ck114 = 1.1 time = 575
* CHECK dout0_1 vdout0_1ck114 = 1.1 time = 575
* CHECK dout0_2 vdout0_2ck114 = 1.1 time = 575
* CHECK dout0_3 vdout0_3ck114 = 1.1 time = 575
* CHECK dout0_4 vdout0_4ck114 = 0 time = 575
* CHECK dout0_5 vdout0_5ck114 = 0 time = 575
* CHECK dout0_6 vdout0_6ck114 = 1.1 time = 575
* CHECK dout0_7 vdout0_7ck114 = 0 time = 575
* CHECK dout0_8 vdout0_8ck114 = 1.1 time = 575
* CHECK dout0_9 vdout0_9ck114 = 0 time = 575
* CHECK dout0_10 vdout0_10ck114 = 1.1 time = 575
* CHECK dout0_11 vdout0_11ck114 = 1.1 time = 575
* CHECK dout0_12 vdout0_12ck114 = 0 time = 575
* CHECK dout0_13 vdout0_13ck114 = 0 time = 575
* CHECK dout0_14 vdout0_14ck114 = 1.1 time = 575
* CHECK dout0_15 vdout0_15ck114 = 1.1 time = 575
* CHECK dout0_16 vdout0_16ck114 = 0 time = 575
* CHECK dout0_17 vdout0_17ck114 = 1.1 time = 575
* CHECK dout0_18 vdout0_18ck114 = 0 time = 575
* CHECK dout0_19 vdout0_19ck114 = 0 time = 575
* CHECK dout0_20 vdout0_20ck114 = 1.1 time = 575
* CHECK dout0_21 vdout0_21ck114 = 0 time = 575
* CHECK dout0_22 vdout0_22ck114 = 0 time = 575
* CHECK dout0_23 vdout0_23ck114 = 0 time = 575
* CHECK dout0_24 vdout0_24ck114 = 0 time = 575
* CHECK dout0_25 vdout0_25ck114 = 0 time = 575
* CHECK dout0_26 vdout0_26ck114 = 1.1 time = 575
* CHECK dout0_27 vdout0_27ck114 = 1.1 time = 575
* CHECK dout0_28 vdout0_28ck114 = 0 time = 575
* CHECK dout0_29 vdout0_29ck114 = 1.1 time = 575
* CHECK dout0_30 vdout0_30ck114 = 1.1 time = 575
* CHECK dout0_31 vdout0_31ck114 = 1.1 time = 575
* CHECK dout0_0 vdout0_0ck115 = 0 time = 580
* CHECK dout0_1 vdout0_1ck115 = 1.1 time = 580
* CHECK dout0_2 vdout0_2ck115 = 1.1 time = 580
* CHECK dout0_3 vdout0_3ck115 = 1.1 time = 580
* CHECK dout0_4 vdout0_4ck115 = 1.1 time = 580
* CHECK dout0_5 vdout0_5ck115 = 1.1 time = 580
* CHECK dout0_6 vdout0_6ck115 = 0 time = 580
* CHECK dout0_7 vdout0_7ck115 = 0 time = 580
* CHECK dout0_8 vdout0_8ck115 = 0 time = 580
* CHECK dout0_9 vdout0_9ck115 = 0 time = 580
* CHECK dout0_10 vdout0_10ck115 = 1.1 time = 580
* CHECK dout0_11 vdout0_11ck115 = 1.1 time = 580
* CHECK dout0_12 vdout0_12ck115 = 0 time = 580
* CHECK dout0_13 vdout0_13ck115 = 0 time = 580
* CHECK dout0_14 vdout0_14ck115 = 1.1 time = 580
* CHECK dout0_15 vdout0_15ck115 = 0 time = 580
* CHECK dout0_16 vdout0_16ck115 = 0 time = 580
* CHECK dout0_17 vdout0_17ck115 = 1.1 time = 580
* CHECK dout0_18 vdout0_18ck115 = 1.1 time = 580
* CHECK dout0_19 vdout0_19ck115 = 0 time = 580
* CHECK dout0_20 vdout0_20ck115 = 1.1 time = 580
* CHECK dout0_21 vdout0_21ck115 = 0 time = 580
* CHECK dout0_22 vdout0_22ck115 = 0 time = 580
* CHECK dout0_23 vdout0_23ck115 = 0 time = 580
* CHECK dout0_24 vdout0_24ck115 = 0 time = 580
* CHECK dout0_25 vdout0_25ck115 = 1.1 time = 580
* CHECK dout0_26 vdout0_26ck115 = 1.1 time = 580
* CHECK dout0_27 vdout0_27ck115 = 1.1 time = 580
* CHECK dout0_28 vdout0_28ck115 = 0 time = 580
* CHECK dout0_29 vdout0_29ck115 = 0 time = 580
* CHECK dout0_30 vdout0_30ck115 = 1.1 time = 580
* CHECK dout0_31 vdout0_31ck115 = 1.1 time = 580
* CHECK dout0_0 vdout0_0ck116 = 0 time = 585
* CHECK dout0_1 vdout0_1ck116 = 1.1 time = 585
* CHECK dout0_2 vdout0_2ck116 = 1.1 time = 585
* CHECK dout0_3 vdout0_3ck116 = 1.1 time = 585
* CHECK dout0_4 vdout0_4ck116 = 1.1 time = 585
* CHECK dout0_5 vdout0_5ck116 = 1.1 time = 585
* CHECK dout0_6 vdout0_6ck116 = 0 time = 585
* CHECK dout0_7 vdout0_7ck116 = 0 time = 585
* CHECK dout0_8 vdout0_8ck116 = 0 time = 585
* CHECK dout0_9 vdout0_9ck116 = 0 time = 585
* CHECK dout0_10 vdout0_10ck116 = 1.1 time = 585
* CHECK dout0_11 vdout0_11ck116 = 1.1 time = 585
* CHECK dout0_12 vdout0_12ck116 = 0 time = 585
* CHECK dout0_13 vdout0_13ck116 = 0 time = 585
* CHECK dout0_14 vdout0_14ck116 = 1.1 time = 585
* CHECK dout0_15 vdout0_15ck116 = 0 time = 585
* CHECK dout0_16 vdout0_16ck116 = 0 time = 585
* CHECK dout0_17 vdout0_17ck116 = 1.1 time = 585
* CHECK dout0_18 vdout0_18ck116 = 1.1 time = 585
* CHECK dout0_19 vdout0_19ck116 = 0 time = 585
* CHECK dout0_20 vdout0_20ck116 = 1.1 time = 585
* CHECK dout0_21 vdout0_21ck116 = 0 time = 585
* CHECK dout0_22 vdout0_22ck116 = 0 time = 585
* CHECK dout0_23 vdout0_23ck116 = 0 time = 585
* CHECK dout0_24 vdout0_24ck116 = 0 time = 585
* CHECK dout0_25 vdout0_25ck116 = 1.1 time = 585
* CHECK dout0_26 vdout0_26ck116 = 1.1 time = 585
* CHECK dout0_27 vdout0_27ck116 = 1.1 time = 585
* CHECK dout0_28 vdout0_28ck116 = 0 time = 585
* CHECK dout0_29 vdout0_29ck116 = 0 time = 585
* CHECK dout0_30 vdout0_30ck116 = 1.1 time = 585
* CHECK dout0_31 vdout0_31ck116 = 1.1 time = 585
* CHECK dout0_0 vdout0_0ck117 = 1.1 time = 590
* CHECK dout0_1 vdout0_1ck117 = 1.1 time = 590
* CHECK dout0_2 vdout0_2ck117 = 0 time = 590
* CHECK dout0_3 vdout0_3ck117 = 0 time = 590
* CHECK dout0_4 vdout0_4ck117 = 0 time = 590
* CHECK dout0_5 vdout0_5ck117 = 1.1 time = 590
* CHECK dout0_6 vdout0_6ck117 = 0 time = 590
* CHECK dout0_7 vdout0_7ck117 = 0 time = 590
* CHECK dout0_8 vdout0_8ck117 = 1.1 time = 590
* CHECK dout0_9 vdout0_9ck117 = 1.1 time = 590
* CHECK dout0_10 vdout0_10ck117 = 0 time = 590
* CHECK dout0_11 vdout0_11ck117 = 1.1 time = 590
* CHECK dout0_12 vdout0_12ck117 = 0 time = 590
* CHECK dout0_13 vdout0_13ck117 = 0 time = 590
* CHECK dout0_14 vdout0_14ck117 = 1.1 time = 590
* CHECK dout0_15 vdout0_15ck117 = 1.1 time = 590
* CHECK dout0_16 vdout0_16ck117 = 0 time = 590
* CHECK dout0_17 vdout0_17ck117 = 1.1 time = 590
* CHECK dout0_18 vdout0_18ck117 = 0 time = 590
* CHECK dout0_19 vdout0_19ck117 = 1.1 time = 590
* CHECK dout0_20 vdout0_20ck117 = 1.1 time = 590
* CHECK dout0_21 vdout0_21ck117 = 1.1 time = 590
* CHECK dout0_22 vdout0_22ck117 = 0 time = 590
* CHECK dout0_23 vdout0_23ck117 = 1.1 time = 590
* CHECK dout0_24 vdout0_24ck117 = 1.1 time = 590
* CHECK dout0_25 vdout0_25ck117 = 0 time = 590
* CHECK dout0_26 vdout0_26ck117 = 0 time = 590
* CHECK dout0_27 vdout0_27ck117 = 0 time = 590
* CHECK dout0_28 vdout0_28ck117 = 0 time = 590
* CHECK dout0_29 vdout0_29ck117 = 0 time = 590
* CHECK dout0_30 vdout0_30ck117 = 1.1 time = 590
* CHECK dout0_31 vdout0_31ck117 = 1.1 time = 590
* CHECK dout0_0 vdout0_0ck118 = 0 time = 595
* CHECK dout0_1 vdout0_1ck118 = 0 time = 595
* CHECK dout0_2 vdout0_2ck118 = 1.1 time = 595
* CHECK dout0_3 vdout0_3ck118 = 1.1 time = 595
* CHECK dout0_4 vdout0_4ck118 = 0 time = 595
* CHECK dout0_5 vdout0_5ck118 = 0 time = 595
* CHECK dout0_6 vdout0_6ck118 = 1.1 time = 595
* CHECK dout0_7 vdout0_7ck118 = 0 time = 595
* CHECK dout0_8 vdout0_8ck118 = 0 time = 595
* CHECK dout0_9 vdout0_9ck118 = 1.1 time = 595
* CHECK dout0_10 vdout0_10ck118 = 1.1 time = 595
* CHECK dout0_11 vdout0_11ck118 = 0 time = 595
* CHECK dout0_12 vdout0_12ck118 = 0 time = 595
* CHECK dout0_13 vdout0_13ck118 = 1.1 time = 595
* CHECK dout0_14 vdout0_14ck118 = 0 time = 595
* CHECK dout0_15 vdout0_15ck118 = 0 time = 595
* CHECK dout0_16 vdout0_16ck118 = 1.1 time = 595
* CHECK dout0_17 vdout0_17ck118 = 0 time = 595
* CHECK dout0_18 vdout0_18ck118 = 0 time = 595
* CHECK dout0_19 vdout0_19ck118 = 1.1 time = 595
* CHECK dout0_20 vdout0_20ck118 = 0 time = 595
* CHECK dout0_21 vdout0_21ck118 = 0 time = 595
* CHECK dout0_22 vdout0_22ck118 = 0 time = 595
* CHECK dout0_23 vdout0_23ck118 = 1.1 time = 595
* CHECK dout0_24 vdout0_24ck118 = 0 time = 595
* CHECK dout0_25 vdout0_25ck118 = 0 time = 595
* CHECK dout0_26 vdout0_26ck118 = 1.1 time = 595
* CHECK dout0_27 vdout0_27ck118 = 0 time = 595
* CHECK dout0_28 vdout0_28ck118 = 0 time = 595
* CHECK dout0_29 vdout0_29ck118 = 0 time = 595
* CHECK dout0_30 vdout0_30ck118 = 1.1 time = 595
* CHECK dout0_31 vdout0_31ck118 = 1.1 time = 595
* CHECK dout0_0 vdout0_0ck121 = 0 time = 610
* CHECK dout0_1 vdout0_1ck121 = 0 time = 610
* CHECK dout0_2 vdout0_2ck121 = 1.1 time = 610
* CHECK dout0_3 vdout0_3ck121 = 1.1 time = 610
* CHECK dout0_4 vdout0_4ck121 = 0 time = 610
* CHECK dout0_5 vdout0_5ck121 = 0 time = 610
* CHECK dout0_6 vdout0_6ck121 = 1.1 time = 610
* CHECK dout0_7 vdout0_7ck121 = 0 time = 610
* CHECK dout0_8 vdout0_8ck121 = 0 time = 610
* CHECK dout0_9 vdout0_9ck121 = 1.1 time = 610
* CHECK dout0_10 vdout0_10ck121 = 1.1 time = 610
* CHECK dout0_11 vdout0_11ck121 = 0 time = 610
* CHECK dout0_12 vdout0_12ck121 = 0 time = 610
* CHECK dout0_13 vdout0_13ck121 = 1.1 time = 610
* CHECK dout0_14 vdout0_14ck121 = 0 time = 610
* CHECK dout0_15 vdout0_15ck121 = 0 time = 610
* CHECK dout0_16 vdout0_16ck121 = 1.1 time = 610
* CHECK dout0_17 vdout0_17ck121 = 0 time = 610
* CHECK dout0_18 vdout0_18ck121 = 0 time = 610
* CHECK dout0_19 vdout0_19ck121 = 1.1 time = 610
* CHECK dout0_20 vdout0_20ck121 = 0 time = 610
* CHECK dout0_21 vdout0_21ck121 = 0 time = 610
* CHECK dout0_22 vdout0_22ck121 = 0 time = 610
* CHECK dout0_23 vdout0_23ck121 = 1.1 time = 610
* CHECK dout0_24 vdout0_24ck121 = 0 time = 610
* CHECK dout0_25 vdout0_25ck121 = 0 time = 610
* CHECK dout0_26 vdout0_26ck121 = 1.1 time = 610
* CHECK dout0_27 vdout0_27ck121 = 0 time = 610
* CHECK dout0_28 vdout0_28ck121 = 0 time = 610
* CHECK dout0_29 vdout0_29ck121 = 0 time = 610
* CHECK dout0_30 vdout0_30ck121 = 1.1 time = 610
* CHECK dout0_31 vdout0_31ck121 = 1.1 time = 610
* CHECK dout0_0 vdout0_0ck125 = 1.1 time = 630
* CHECK dout0_1 vdout0_1ck125 = 1.1 time = 630
* CHECK dout0_2 vdout0_2ck125 = 1.1 time = 630
* CHECK dout0_3 vdout0_3ck125 = 1.1 time = 630
* CHECK dout0_4 vdout0_4ck125 = 0 time = 630
* CHECK dout0_5 vdout0_5ck125 = 0 time = 630
* CHECK dout0_6 vdout0_6ck125 = 1.1 time = 630
* CHECK dout0_7 vdout0_7ck125 = 0 time = 630
* CHECK dout0_8 vdout0_8ck125 = 1.1 time = 630
* CHECK dout0_9 vdout0_9ck125 = 0 time = 630
* CHECK dout0_10 vdout0_10ck125 = 1.1 time = 630
* CHECK dout0_11 vdout0_11ck125 = 1.1 time = 630
* CHECK dout0_12 vdout0_12ck125 = 0 time = 630
* CHECK dout0_13 vdout0_13ck125 = 0 time = 630
* CHECK dout0_14 vdout0_14ck125 = 1.1 time = 630
* CHECK dout0_15 vdout0_15ck125 = 1.1 time = 630
* CHECK dout0_16 vdout0_16ck125 = 0 time = 630
* CHECK dout0_17 vdout0_17ck125 = 1.1 time = 630
* CHECK dout0_18 vdout0_18ck125 = 0 time = 630
* CHECK dout0_19 vdout0_19ck125 = 0 time = 630
* CHECK dout0_20 vdout0_20ck125 = 1.1 time = 630
* CHECK dout0_21 vdout0_21ck125 = 0 time = 630
* CHECK dout0_22 vdout0_22ck125 = 0 time = 630
* CHECK dout0_23 vdout0_23ck125 = 0 time = 630
* CHECK dout0_24 vdout0_24ck125 = 0 time = 630
* CHECK dout0_25 vdout0_25ck125 = 0 time = 630
* CHECK dout0_26 vdout0_26ck125 = 1.1 time = 630
* CHECK dout0_27 vdout0_27ck125 = 1.1 time = 630
* CHECK dout0_28 vdout0_28ck125 = 0 time = 630
* CHECK dout0_29 vdout0_29ck125 = 1.1 time = 630
* CHECK dout0_30 vdout0_30ck125 = 1.1 time = 630
* CHECK dout0_31 vdout0_31ck125 = 1.1 time = 630
* CHECK dout0_0 vdout0_0ck128 = 1.1 time = 645
* CHECK dout0_1 vdout0_1ck128 = 1.1 time = 645
* CHECK dout0_2 vdout0_2ck128 = 0 time = 645
* CHECK dout0_3 vdout0_3ck128 = 1.1 time = 645
* CHECK dout0_4 vdout0_4ck128 = 1.1 time = 645
* CHECK dout0_5 vdout0_5ck128 = 1.1 time = 645
* CHECK dout0_6 vdout0_6ck128 = 0 time = 645
* CHECK dout0_7 vdout0_7ck128 = 0 time = 645
* CHECK dout0_8 vdout0_8ck128 = 0 time = 645
* CHECK dout0_9 vdout0_9ck128 = 1.1 time = 645
* CHECK dout0_10 vdout0_10ck128 = 0 time = 645
* CHECK dout0_11 vdout0_11ck128 = 0 time = 645
* CHECK dout0_12 vdout0_12ck128 = 1.1 time = 645
* CHECK dout0_13 vdout0_13ck128 = 0 time = 645
* CHECK dout0_14 vdout0_14ck128 = 1.1 time = 645
* CHECK dout0_15 vdout0_15ck128 = 0 time = 645
* CHECK dout0_16 vdout0_16ck128 = 0 time = 645
* CHECK dout0_17 vdout0_17ck128 = 1.1 time = 645
* CHECK dout0_18 vdout0_18ck128 = 1.1 time = 645
* CHECK dout0_19 vdout0_19ck128 = 1.1 time = 645
* CHECK dout0_20 vdout0_20ck128 = 1.1 time = 645
* CHECK dout0_21 vdout0_21ck128 = 1.1 time = 645
* CHECK dout0_22 vdout0_22ck128 = 1.1 time = 645
* CHECK dout0_23 vdout0_23ck128 = 1.1 time = 645
* CHECK dout0_24 vdout0_24ck128 = 0 time = 645
* CHECK dout0_25 vdout0_25ck128 = 0 time = 645
* CHECK dout0_26 vdout0_26ck128 = 0 time = 645
* CHECK dout0_27 vdout0_27ck128 = 0 time = 645
* CHECK dout0_28 vdout0_28ck128 = 0 time = 645
* CHECK dout0_29 vdout0_29ck128 = 1.1 time = 645
* CHECK dout0_30 vdout0_30ck128 = 0 time = 645
* CHECK dout0_31 vdout0_31ck128 = 1.1 time = 645
* CHECK dout0_0 vdout0_0ck130 = 0 time = 655
* CHECK dout0_1 vdout0_1ck130 = 0 time = 655
* CHECK dout0_2 vdout0_2ck130 = 1.1 time = 655
* CHECK dout0_3 vdout0_3ck130 = 1.1 time = 655
* CHECK dout0_4 vdout0_4ck130 = 0 time = 655
* CHECK dout0_5 vdout0_5ck130 = 0 time = 655
* CHECK dout0_6 vdout0_6ck130 = 1.1 time = 655
* CHECK dout0_7 vdout0_7ck130 = 0 time = 655
* CHECK dout0_8 vdout0_8ck130 = 0 time = 655
* CHECK dout0_9 vdout0_9ck130 = 1.1 time = 655
* CHECK dout0_10 vdout0_10ck130 = 1.1 time = 655
* CHECK dout0_11 vdout0_11ck130 = 0 time = 655
* CHECK dout0_12 vdout0_12ck130 = 0 time = 655
* CHECK dout0_13 vdout0_13ck130 = 1.1 time = 655
* CHECK dout0_14 vdout0_14ck130 = 0 time = 655
* CHECK dout0_15 vdout0_15ck130 = 0 time = 655
* CHECK dout0_16 vdout0_16ck130 = 1.1 time = 655
* CHECK dout0_17 vdout0_17ck130 = 0 time = 655
* CHECK dout0_18 vdout0_18ck130 = 0 time = 655
* CHECK dout0_19 vdout0_19ck130 = 1.1 time = 655
* CHECK dout0_20 vdout0_20ck130 = 0 time = 655
* CHECK dout0_21 vdout0_21ck130 = 0 time = 655
* CHECK dout0_22 vdout0_22ck130 = 0 time = 655
* CHECK dout0_23 vdout0_23ck130 = 1.1 time = 655
* CHECK dout0_24 vdout0_24ck130 = 0 time = 655
* CHECK dout0_25 vdout0_25ck130 = 0 time = 655
* CHECK dout0_26 vdout0_26ck130 = 1.1 time = 655
* CHECK dout0_27 vdout0_27ck130 = 0 time = 655
* CHECK dout0_28 vdout0_28ck130 = 0 time = 655
* CHECK dout0_29 vdout0_29ck130 = 0 time = 655
* CHECK dout0_30 vdout0_30ck130 = 1.1 time = 655
* CHECK dout0_31 vdout0_31ck130 = 1.1 time = 655
* CHECK dout0_0 vdout0_0ck131 = 1.1 time = 660
* CHECK dout0_1 vdout0_1ck131 = 1.1 time = 660
* CHECK dout0_2 vdout0_2ck131 = 0 time = 660
* CHECK dout0_3 vdout0_3ck131 = 0 time = 660
* CHECK dout0_4 vdout0_4ck131 = 0 time = 660
* CHECK dout0_5 vdout0_5ck131 = 1.1 time = 660
* CHECK dout0_6 vdout0_6ck131 = 0 time = 660
* CHECK dout0_7 vdout0_7ck131 = 0 time = 660
* CHECK dout0_8 vdout0_8ck131 = 1.1 time = 660
* CHECK dout0_9 vdout0_9ck131 = 1.1 time = 660
* CHECK dout0_10 vdout0_10ck131 = 0 time = 660
* CHECK dout0_11 vdout0_11ck131 = 1.1 time = 660
* CHECK dout0_12 vdout0_12ck131 = 0 time = 660
* CHECK dout0_13 vdout0_13ck131 = 0 time = 660
* CHECK dout0_14 vdout0_14ck131 = 1.1 time = 660
* CHECK dout0_15 vdout0_15ck131 = 1.1 time = 660
* CHECK dout0_16 vdout0_16ck131 = 0 time = 660
* CHECK dout0_17 vdout0_17ck131 = 1.1 time = 660
* CHECK dout0_18 vdout0_18ck131 = 0 time = 660
* CHECK dout0_19 vdout0_19ck131 = 1.1 time = 660
* CHECK dout0_20 vdout0_20ck131 = 1.1 time = 660
* CHECK dout0_21 vdout0_21ck131 = 1.1 time = 660
* CHECK dout0_22 vdout0_22ck131 = 0 time = 660
* CHECK dout0_23 vdout0_23ck131 = 1.1 time = 660
* CHECK dout0_24 vdout0_24ck131 = 1.1 time = 660
* CHECK dout0_25 vdout0_25ck131 = 0 time = 660
* CHECK dout0_26 vdout0_26ck131 = 0 time = 660
* CHECK dout0_27 vdout0_27ck131 = 0 time = 660
* CHECK dout0_28 vdout0_28ck131 = 0 time = 660
* CHECK dout0_29 vdout0_29ck131 = 0 time = 660
* CHECK dout0_30 vdout0_30ck131 = 1.1 time = 660
* CHECK dout0_31 vdout0_31ck131 = 1.1 time = 660
* CHECK dout0_0 vdout0_0ck134 = 1.1 time = 675
* CHECK dout0_1 vdout0_1ck134 = 1.1 time = 675
* CHECK dout0_2 vdout0_2ck134 = 0 time = 675
* CHECK dout0_3 vdout0_3ck134 = 0 time = 675
* CHECK dout0_4 vdout0_4ck134 = 0 time = 675
* CHECK dout0_5 vdout0_5ck134 = 1.1 time = 675
* CHECK dout0_6 vdout0_6ck134 = 0 time = 675
* CHECK dout0_7 vdout0_7ck134 = 0 time = 675
* CHECK dout0_8 vdout0_8ck134 = 1.1 time = 675
* CHECK dout0_9 vdout0_9ck134 = 1.1 time = 675
* CHECK dout0_10 vdout0_10ck134 = 0 time = 675
* CHECK dout0_11 vdout0_11ck134 = 1.1 time = 675
* CHECK dout0_12 vdout0_12ck134 = 0 time = 675
* CHECK dout0_13 vdout0_13ck134 = 0 time = 675
* CHECK dout0_14 vdout0_14ck134 = 1.1 time = 675
* CHECK dout0_15 vdout0_15ck134 = 1.1 time = 675
* CHECK dout0_16 vdout0_16ck134 = 0 time = 675
* CHECK dout0_17 vdout0_17ck134 = 1.1 time = 675
* CHECK dout0_18 vdout0_18ck134 = 0 time = 675
* CHECK dout0_19 vdout0_19ck134 = 1.1 time = 675
* CHECK dout0_20 vdout0_20ck134 = 1.1 time = 675
* CHECK dout0_21 vdout0_21ck134 = 1.1 time = 675
* CHECK dout0_22 vdout0_22ck134 = 0 time = 675
* CHECK dout0_23 vdout0_23ck134 = 1.1 time = 675
* CHECK dout0_24 vdout0_24ck134 = 1.1 time = 675
* CHECK dout0_25 vdout0_25ck134 = 0 time = 675
* CHECK dout0_26 vdout0_26ck134 = 0 time = 675
* CHECK dout0_27 vdout0_27ck134 = 0 time = 675
* CHECK dout0_28 vdout0_28ck134 = 0 time = 675
* CHECK dout0_29 vdout0_29ck134 = 0 time = 675
* CHECK dout0_30 vdout0_30ck134 = 1.1 time = 675
* CHECK dout0_31 vdout0_31ck134 = 1.1 time = 675
* CHECK dout0_0 vdout0_0ck137 = 0 time = 690
* CHECK dout0_1 vdout0_1ck137 = 1.1 time = 690
* CHECK dout0_2 vdout0_2ck137 = 0 time = 690
* CHECK dout0_3 vdout0_3ck137 = 1.1 time = 690
* CHECK dout0_4 vdout0_4ck137 = 0 time = 690
* CHECK dout0_5 vdout0_5ck137 = 0 time = 690
* CHECK dout0_6 vdout0_6ck137 = 0 time = 690
* CHECK dout0_7 vdout0_7ck137 = 1.1 time = 690
* CHECK dout0_8 vdout0_8ck137 = 0 time = 690
* CHECK dout0_9 vdout0_9ck137 = 0 time = 690
* CHECK dout0_10 vdout0_10ck137 = 1.1 time = 690
* CHECK dout0_11 vdout0_11ck137 = 0 time = 690
* CHECK dout0_12 vdout0_12ck137 = 1.1 time = 690
* CHECK dout0_13 vdout0_13ck137 = 1.1 time = 690
* CHECK dout0_14 vdout0_14ck137 = 0 time = 690
* CHECK dout0_15 vdout0_15ck137 = 1.1 time = 690
* CHECK dout0_16 vdout0_16ck137 = 1.1 time = 690
* CHECK dout0_17 vdout0_17ck137 = 0 time = 690
* CHECK dout0_18 vdout0_18ck137 = 1.1 time = 690
* CHECK dout0_19 vdout0_19ck137 = 1.1 time = 690
* CHECK dout0_20 vdout0_20ck137 = 1.1 time = 690
* CHECK dout0_21 vdout0_21ck137 = 0 time = 690
* CHECK dout0_22 vdout0_22ck137 = 1.1 time = 690
* CHECK dout0_23 vdout0_23ck137 = 1.1 time = 690
* CHECK dout0_24 vdout0_24ck137 = 1.1 time = 690
* CHECK dout0_25 vdout0_25ck137 = 0 time = 690
* CHECK dout0_26 vdout0_26ck137 = 0 time = 690
* CHECK dout0_27 vdout0_27ck137 = 1.1 time = 690
* CHECK dout0_28 vdout0_28ck137 = 0 time = 690
* CHECK dout0_29 vdout0_29ck137 = 1.1 time = 690
* CHECK dout0_30 vdout0_30ck137 = 0 time = 690
* CHECK dout0_31 vdout0_31ck137 = 1.1 time = 690
* CHECK dout0_0 vdout0_0ck138 = 1.1 time = 695
* CHECK dout0_1 vdout0_1ck138 = 1.1 time = 695
* CHECK dout0_2 vdout0_2ck138 = 1.1 time = 695
* CHECK dout0_3 vdout0_3ck138 = 1.1 time = 695
* CHECK dout0_4 vdout0_4ck138 = 1.1 time = 695
* CHECK dout0_5 vdout0_5ck138 = 0 time = 695
* CHECK dout0_6 vdout0_6ck138 = 1.1 time = 695
* CHECK dout0_7 vdout0_7ck138 = 1.1 time = 695
* CHECK dout0_8 vdout0_8ck138 = 0 time = 695
* CHECK dout0_9 vdout0_9ck138 = 0 time = 695
* CHECK dout0_10 vdout0_10ck138 = 0 time = 695
* CHECK dout0_11 vdout0_11ck138 = 1.1 time = 695
* CHECK dout0_12 vdout0_12ck138 = 0 time = 695
* CHECK dout0_13 vdout0_13ck138 = 1.1 time = 695
* CHECK dout0_14 vdout0_14ck138 = 0 time = 695
* CHECK dout0_15 vdout0_15ck138 = 1.1 time = 695
* CHECK dout0_16 vdout0_16ck138 = 0 time = 695
* CHECK dout0_17 vdout0_17ck138 = 0 time = 695
* CHECK dout0_18 vdout0_18ck138 = 1.1 time = 695
* CHECK dout0_19 vdout0_19ck138 = 1.1 time = 695
* CHECK dout0_20 vdout0_20ck138 = 1.1 time = 695
* CHECK dout0_21 vdout0_21ck138 = 1.1 time = 695
* CHECK dout0_22 vdout0_22ck138 = 1.1 time = 695
* CHECK dout0_23 vdout0_23ck138 = 1.1 time = 695
* CHECK dout0_24 vdout0_24ck138 = 1.1 time = 695
* CHECK dout0_25 vdout0_25ck138 = 0 time = 695
* CHECK dout0_26 vdout0_26ck138 = 1.1 time = 695
* CHECK dout0_27 vdout0_27ck138 = 1.1 time = 695
* CHECK dout0_28 vdout0_28ck138 = 1.1 time = 695
* CHECK dout0_29 vdout0_29ck138 = 1.1 time = 695
* CHECK dout0_30 vdout0_30ck138 = 0 time = 695
* CHECK dout0_31 vdout0_31ck138 = 0 time = 695
* CHECK dout0_0 vdout0_0ck139 = 0 time = 700
* CHECK dout0_1 vdout0_1ck139 = 0 time = 700
* CHECK dout0_2 vdout0_2ck139 = 1.1 time = 700
* CHECK dout0_3 vdout0_3ck139 = 0 time = 700
* CHECK dout0_4 vdout0_4ck139 = 0 time = 700
* CHECK dout0_5 vdout0_5ck139 = 1.1 time = 700
* CHECK dout0_6 vdout0_6ck139 = 1.1 time = 700
* CHECK dout0_7 vdout0_7ck139 = 1.1 time = 700
* CHECK dout0_8 vdout0_8ck139 = 1.1 time = 700
* CHECK dout0_9 vdout0_9ck139 = 0 time = 700
* CHECK dout0_10 vdout0_10ck139 = 0 time = 700
* CHECK dout0_11 vdout0_11ck139 = 0 time = 700
* CHECK dout0_12 vdout0_12ck139 = 1.1 time = 700
* CHECK dout0_13 vdout0_13ck139 = 0 time = 700
* CHECK dout0_14 vdout0_14ck139 = 1.1 time = 700
* CHECK dout0_15 vdout0_15ck139 = 1.1 time = 700
* CHECK dout0_16 vdout0_16ck139 = 1.1 time = 700
* CHECK dout0_17 vdout0_17ck139 = 0 time = 700
* CHECK dout0_18 vdout0_18ck139 = 1.1 time = 700
* CHECK dout0_19 vdout0_19ck139 = 1.1 time = 700
* CHECK dout0_20 vdout0_20ck139 = 0 time = 700
* CHECK dout0_21 vdout0_21ck139 = 1.1 time = 700
* CHECK dout0_22 vdout0_22ck139 = 0 time = 700
* CHECK dout0_23 vdout0_23ck139 = 1.1 time = 700
* CHECK dout0_24 vdout0_24ck139 = 1.1 time = 700
* CHECK dout0_25 vdout0_25ck139 = 0 time = 700
* CHECK dout0_26 vdout0_26ck139 = 0 time = 700
* CHECK dout0_27 vdout0_27ck139 = 0 time = 700
* CHECK dout0_28 vdout0_28ck139 = 1.1 time = 700
* CHECK dout0_29 vdout0_29ck139 = 1.1 time = 700
* CHECK dout0_30 vdout0_30ck139 = 1.1 time = 700
* CHECK dout0_31 vdout0_31ck139 = 1.1 time = 700
* CHECK dout0_0 vdout0_0ck141 = 0 time = 710
* CHECK dout0_1 vdout0_1ck141 = 0 time = 710
* CHECK dout0_2 vdout0_2ck141 = 1.1 time = 710
* CHECK dout0_3 vdout0_3ck141 = 0 time = 710
* CHECK dout0_4 vdout0_4ck141 = 0 time = 710
* CHECK dout0_5 vdout0_5ck141 = 1.1 time = 710
* CHECK dout0_6 vdout0_6ck141 = 1.1 time = 710
* CHECK dout0_7 vdout0_7ck141 = 1.1 time = 710
* CHECK dout0_8 vdout0_8ck141 = 1.1 time = 710
* CHECK dout0_9 vdout0_9ck141 = 0 time = 710
* CHECK dout0_10 vdout0_10ck141 = 0 time = 710
* CHECK dout0_11 vdout0_11ck141 = 0 time = 710
* CHECK dout0_12 vdout0_12ck141 = 1.1 time = 710
* CHECK dout0_13 vdout0_13ck141 = 0 time = 710
* CHECK dout0_14 vdout0_14ck141 = 1.1 time = 710
* CHECK dout0_15 vdout0_15ck141 = 1.1 time = 710
* CHECK dout0_16 vdout0_16ck141 = 1.1 time = 710
* CHECK dout0_17 vdout0_17ck141 = 0 time = 710
* CHECK dout0_18 vdout0_18ck141 = 1.1 time = 710
* CHECK dout0_19 vdout0_19ck141 = 1.1 time = 710
* CHECK dout0_20 vdout0_20ck141 = 0 time = 710
* CHECK dout0_21 vdout0_21ck141 = 1.1 time = 710
* CHECK dout0_22 vdout0_22ck141 = 0 time = 710
* CHECK dout0_23 vdout0_23ck141 = 1.1 time = 710
* CHECK dout0_24 vdout0_24ck141 = 1.1 time = 710
* CHECK dout0_25 vdout0_25ck141 = 0 time = 710
* CHECK dout0_26 vdout0_26ck141 = 0 time = 710
* CHECK dout0_27 vdout0_27ck141 = 0 time = 710
* CHECK dout0_28 vdout0_28ck141 = 1.1 time = 710
* CHECK dout0_29 vdout0_29ck141 = 1.1 time = 710
* CHECK dout0_30 vdout0_30ck141 = 1.1 time = 710
* CHECK dout0_31 vdout0_31ck141 = 1.1 time = 710
* CHECK dout0_0 vdout0_0ck144 = 1.1 time = 725
* CHECK dout0_1 vdout0_1ck144 = 1.1 time = 725
* CHECK dout0_2 vdout0_2ck144 = 0 time = 725
* CHECK dout0_3 vdout0_3ck144 = 1.1 time = 725
* CHECK dout0_4 vdout0_4ck144 = 1.1 time = 725
* CHECK dout0_5 vdout0_5ck144 = 1.1 time = 725
* CHECK dout0_6 vdout0_6ck144 = 0 time = 725
* CHECK dout0_7 vdout0_7ck144 = 0 time = 725
* CHECK dout0_8 vdout0_8ck144 = 0 time = 725
* CHECK dout0_9 vdout0_9ck144 = 1.1 time = 725
* CHECK dout0_10 vdout0_10ck144 = 0 time = 725
* CHECK dout0_11 vdout0_11ck144 = 0 time = 725
* CHECK dout0_12 vdout0_12ck144 = 1.1 time = 725
* CHECK dout0_13 vdout0_13ck144 = 0 time = 725
* CHECK dout0_14 vdout0_14ck144 = 1.1 time = 725
* CHECK dout0_15 vdout0_15ck144 = 0 time = 725
* CHECK dout0_16 vdout0_16ck144 = 0 time = 725
* CHECK dout0_17 vdout0_17ck144 = 1.1 time = 725
* CHECK dout0_18 vdout0_18ck144 = 1.1 time = 725
* CHECK dout0_19 vdout0_19ck144 = 1.1 time = 725
* CHECK dout0_20 vdout0_20ck144 = 1.1 time = 725
* CHECK dout0_21 vdout0_21ck144 = 1.1 time = 725
* CHECK dout0_22 vdout0_22ck144 = 1.1 time = 725
* CHECK dout0_23 vdout0_23ck144 = 1.1 time = 725
* CHECK dout0_24 vdout0_24ck144 = 0 time = 725
* CHECK dout0_25 vdout0_25ck144 = 0 time = 725
* CHECK dout0_26 vdout0_26ck144 = 0 time = 725
* CHECK dout0_27 vdout0_27ck144 = 0 time = 725
* CHECK dout0_28 vdout0_28ck144 = 0 time = 725
* CHECK dout0_29 vdout0_29ck144 = 1.1 time = 725
* CHECK dout0_30 vdout0_30ck144 = 0 time = 725
* CHECK dout0_31 vdout0_31ck144 = 1.1 time = 725
* CHECK dout0_0 vdout0_0ck146 = 1.1 time = 735
* CHECK dout0_1 vdout0_1ck146 = 1.1 time = 735
* CHECK dout0_2 vdout0_2ck146 = 0 time = 735
* CHECK dout0_3 vdout0_3ck146 = 0 time = 735
* CHECK dout0_4 vdout0_4ck146 = 0 time = 735
* CHECK dout0_5 vdout0_5ck146 = 1.1 time = 735
* CHECK dout0_6 vdout0_6ck146 = 0 time = 735
* CHECK dout0_7 vdout0_7ck146 = 0 time = 735
* CHECK dout0_8 vdout0_8ck146 = 1.1 time = 735
* CHECK dout0_9 vdout0_9ck146 = 1.1 time = 735
* CHECK dout0_10 vdout0_10ck146 = 0 time = 735
* CHECK dout0_11 vdout0_11ck146 = 1.1 time = 735
* CHECK dout0_12 vdout0_12ck146 = 0 time = 735
* CHECK dout0_13 vdout0_13ck146 = 0 time = 735
* CHECK dout0_14 vdout0_14ck146 = 1.1 time = 735
* CHECK dout0_15 vdout0_15ck146 = 1.1 time = 735
* CHECK dout0_16 vdout0_16ck146 = 0 time = 735
* CHECK dout0_17 vdout0_17ck146 = 1.1 time = 735
* CHECK dout0_18 vdout0_18ck146 = 0 time = 735
* CHECK dout0_19 vdout0_19ck146 = 1.1 time = 735
* CHECK dout0_20 vdout0_20ck146 = 1.1 time = 735
* CHECK dout0_21 vdout0_21ck146 = 1.1 time = 735
* CHECK dout0_22 vdout0_22ck146 = 0 time = 735
* CHECK dout0_23 vdout0_23ck146 = 1.1 time = 735
* CHECK dout0_24 vdout0_24ck146 = 1.1 time = 735
* CHECK dout0_25 vdout0_25ck146 = 0 time = 735
* CHECK dout0_26 vdout0_26ck146 = 0 time = 735
* CHECK dout0_27 vdout0_27ck146 = 0 time = 735
* CHECK dout0_28 vdout0_28ck146 = 0 time = 735
* CHECK dout0_29 vdout0_29ck146 = 0 time = 735
* CHECK dout0_30 vdout0_30ck146 = 1.1 time = 735
* CHECK dout0_31 vdout0_31ck146 = 1.1 time = 735
* CHECK dout0_0 vdout0_0ck147 = 0 time = 740
* CHECK dout0_1 vdout0_1ck147 = 0 time = 740
* CHECK dout0_2 vdout0_2ck147 = 0 time = 740
* CHECK dout0_3 vdout0_3ck147 = 1.1 time = 740
* CHECK dout0_4 vdout0_4ck147 = 1.1 time = 740
* CHECK dout0_5 vdout0_5ck147 = 0 time = 740
* CHECK dout0_6 vdout0_6ck147 = 0 time = 740
* CHECK dout0_7 vdout0_7ck147 = 1.1 time = 740
* CHECK dout0_8 vdout0_8ck147 = 0 time = 740
* CHECK dout0_9 vdout0_9ck147 = 0 time = 740
* CHECK dout0_10 vdout0_10ck147 = 0 time = 740
* CHECK dout0_11 vdout0_11ck147 = 1.1 time = 740
* CHECK dout0_12 vdout0_12ck147 = 0 time = 740
* CHECK dout0_13 vdout0_13ck147 = 0 time = 740
* CHECK dout0_14 vdout0_14ck147 = 1.1 time = 740
* CHECK dout0_15 vdout0_15ck147 = 1.1 time = 740
* CHECK dout0_16 vdout0_16ck147 = 1.1 time = 740
* CHECK dout0_17 vdout0_17ck147 = 1.1 time = 740
* CHECK dout0_18 vdout0_18ck147 = 0 time = 740
* CHECK dout0_19 vdout0_19ck147 = 0 time = 740
* CHECK dout0_20 vdout0_20ck147 = 0 time = 740
* CHECK dout0_21 vdout0_21ck147 = 0 time = 740
* CHECK dout0_22 vdout0_22ck147 = 1.1 time = 740
* CHECK dout0_23 vdout0_23ck147 = 0 time = 740
* CHECK dout0_24 vdout0_24ck147 = 1.1 time = 740
* CHECK dout0_25 vdout0_25ck147 = 1.1 time = 740
* CHECK dout0_26 vdout0_26ck147 = 0 time = 740
* CHECK dout0_27 vdout0_27ck147 = 0 time = 740
* CHECK dout0_28 vdout0_28ck147 = 0 time = 740
* CHECK dout0_29 vdout0_29ck147 = 0 time = 740
* CHECK dout0_30 vdout0_30ck147 = 0 time = 740
* CHECK dout0_31 vdout0_31ck147 = 0 time = 740
* CHECK dout0_0 vdout0_0ck149 = 0 time = 750
* CHECK dout0_1 vdout0_1ck149 = 1.1 time = 750
* CHECK dout0_2 vdout0_2ck149 = 1.1 time = 750
* CHECK dout0_3 vdout0_3ck149 = 1.1 time = 750
* CHECK dout0_4 vdout0_4ck149 = 1.1 time = 750
* CHECK dout0_5 vdout0_5ck149 = 0 time = 750
* CHECK dout0_6 vdout0_6ck149 = 0 time = 750
* CHECK dout0_7 vdout0_7ck149 = 0 time = 750
* CHECK dout0_8 vdout0_8ck149 = 1.1 time = 750
* CHECK dout0_9 vdout0_9ck149 = 1.1 time = 750
* CHECK dout0_10 vdout0_10ck149 = 0 time = 750
* CHECK dout0_11 vdout0_11ck149 = 1.1 time = 750
* CHECK dout0_12 vdout0_12ck149 = 1.1 time = 750
* CHECK dout0_13 vdout0_13ck149 = 0 time = 750
* CHECK dout0_14 vdout0_14ck149 = 1.1 time = 750
* CHECK dout0_15 vdout0_15ck149 = 1.1 time = 750
* CHECK dout0_16 vdout0_16ck149 = 1.1 time = 750
* CHECK dout0_17 vdout0_17ck149 = 0 time = 750
* CHECK dout0_18 vdout0_18ck149 = 1.1 time = 750
* CHECK dout0_19 vdout0_19ck149 = 1.1 time = 750
* CHECK dout0_20 vdout0_20ck149 = 0 time = 750
* CHECK dout0_21 vdout0_21ck149 = 0 time = 750
* CHECK dout0_22 vdout0_22ck149 = 1.1 time = 750
* CHECK dout0_23 vdout0_23ck149 = 0 time = 750
* CHECK dout0_24 vdout0_24ck149 = 1.1 time = 750
* CHECK dout0_25 vdout0_25ck149 = 1.1 time = 750
* CHECK dout0_26 vdout0_26ck149 = 1.1 time = 750
* CHECK dout0_27 vdout0_27ck149 = 1.1 time = 750
* CHECK dout0_28 vdout0_28ck149 = 1.1 time = 750
* CHECK dout0_29 vdout0_29ck149 = 0 time = 750
* CHECK dout0_30 vdout0_30ck149 = 0 time = 750
* CHECK dout0_31 vdout0_31ck149 = 0 time = 750
* CHECK dout0_0 vdout0_0ck151 = 1.1 time = 760
* CHECK dout0_1 vdout0_1ck151 = 0 time = 760
* CHECK dout0_2 vdout0_2ck151 = 0 time = 760
* CHECK dout0_3 vdout0_3ck151 = 0 time = 760
* CHECK dout0_4 vdout0_4ck151 = 0 time = 760
* CHECK dout0_5 vdout0_5ck151 = 0 time = 760
* CHECK dout0_6 vdout0_6ck151 = 0 time = 760
* CHECK dout0_7 vdout0_7ck151 = 1.1 time = 760
* CHECK dout0_8 vdout0_8ck151 = 1.1 time = 760
* CHECK dout0_9 vdout0_9ck151 = 1.1 time = 760
* CHECK dout0_10 vdout0_10ck151 = 1.1 time = 760
* CHECK dout0_11 vdout0_11ck151 = 1.1 time = 760
* CHECK dout0_12 vdout0_12ck151 = 1.1 time = 760
* CHECK dout0_13 vdout0_13ck151 = 1.1 time = 760
* CHECK dout0_14 vdout0_14ck151 = 1.1 time = 760
* CHECK dout0_15 vdout0_15ck151 = 1.1 time = 760
* CHECK dout0_16 vdout0_16ck151 = 0 time = 760
* CHECK dout0_17 vdout0_17ck151 = 1.1 time = 760
* CHECK dout0_18 vdout0_18ck151 = 1.1 time = 760
* CHECK dout0_19 vdout0_19ck151 = 1.1 time = 760
* CHECK dout0_20 vdout0_20ck151 = 0 time = 760
* CHECK dout0_21 vdout0_21ck151 = 1.1 time = 760
* CHECK dout0_22 vdout0_22ck151 = 0 time = 760
* CHECK dout0_23 vdout0_23ck151 = 1.1 time = 760
* CHECK dout0_24 vdout0_24ck151 = 0 time = 760
* CHECK dout0_25 vdout0_25ck151 = 1.1 time = 760
* CHECK dout0_26 vdout0_26ck151 = 0 time = 760
* CHECK dout0_27 vdout0_27ck151 = 0 time = 760
* CHECK dout0_28 vdout0_28ck151 = 1.1 time = 760
* CHECK dout0_29 vdout0_29ck151 = 1.1 time = 760
* CHECK dout0_30 vdout0_30ck151 = 0 time = 760
* CHECK dout0_31 vdout0_31ck151 = 0 time = 760
* CHECK dout0_0 vdout0_0ck153 = 0 time = 770
* CHECK dout0_1 vdout0_1ck153 = 1.1 time = 770
* CHECK dout0_2 vdout0_2ck153 = 1.1 time = 770
* CHECK dout0_3 vdout0_3ck153 = 1.1 time = 770
* CHECK dout0_4 vdout0_4ck153 = 1.1 time = 770
* CHECK dout0_5 vdout0_5ck153 = 0 time = 770
* CHECK dout0_6 vdout0_6ck153 = 0 time = 770
* CHECK dout0_7 vdout0_7ck153 = 0 time = 770
* CHECK dout0_8 vdout0_8ck153 = 1.1 time = 770
* CHECK dout0_9 vdout0_9ck153 = 1.1 time = 770
* CHECK dout0_10 vdout0_10ck153 = 0 time = 770
* CHECK dout0_11 vdout0_11ck153 = 1.1 time = 770
* CHECK dout0_12 vdout0_12ck153 = 1.1 time = 770
* CHECK dout0_13 vdout0_13ck153 = 0 time = 770
* CHECK dout0_14 vdout0_14ck153 = 1.1 time = 770
* CHECK dout0_15 vdout0_15ck153 = 1.1 time = 770
* CHECK dout0_16 vdout0_16ck153 = 1.1 time = 770
* CHECK dout0_17 vdout0_17ck153 = 0 time = 770
* CHECK dout0_18 vdout0_18ck153 = 1.1 time = 770
* CHECK dout0_19 vdout0_19ck153 = 1.1 time = 770
* CHECK dout0_20 vdout0_20ck153 = 0 time = 770
* CHECK dout0_21 vdout0_21ck153 = 0 time = 770
* CHECK dout0_22 vdout0_22ck153 = 1.1 time = 770
* CHECK dout0_23 vdout0_23ck153 = 0 time = 770
* CHECK dout0_24 vdout0_24ck153 = 1.1 time = 770
* CHECK dout0_25 vdout0_25ck153 = 1.1 time = 770
* CHECK dout0_26 vdout0_26ck153 = 1.1 time = 770
* CHECK dout0_27 vdout0_27ck153 = 1.1 time = 770
* CHECK dout0_28 vdout0_28ck153 = 1.1 time = 770
* CHECK dout0_29 vdout0_29ck153 = 0 time = 770
* CHECK dout0_30 vdout0_30ck153 = 0 time = 770
* CHECK dout0_31 vdout0_31ck153 = 0 time = 770
* CHECK dout0_0 vdout0_0ck155 = 1.1 time = 780
* CHECK dout0_1 vdout0_1ck155 = 1.1 time = 780
* CHECK dout0_2 vdout0_2ck155 = 1.1 time = 780
* CHECK dout0_3 vdout0_3ck155 = 1.1 time = 780
* CHECK dout0_4 vdout0_4ck155 = 1.1 time = 780
* CHECK dout0_5 vdout0_5ck155 = 0 time = 780
* CHECK dout0_6 vdout0_6ck155 = 1.1 time = 780
* CHECK dout0_7 vdout0_7ck155 = 1.1 time = 780
* CHECK dout0_8 vdout0_8ck155 = 0 time = 780
* CHECK dout0_9 vdout0_9ck155 = 0 time = 780
* CHECK dout0_10 vdout0_10ck155 = 0 time = 780
* CHECK dout0_11 vdout0_11ck155 = 1.1 time = 780
* CHECK dout0_12 vdout0_12ck155 = 0 time = 780
* CHECK dout0_13 vdout0_13ck155 = 1.1 time = 780
* CHECK dout0_14 vdout0_14ck155 = 0 time = 780
* CHECK dout0_15 vdout0_15ck155 = 1.1 time = 780
* CHECK dout0_16 vdout0_16ck155 = 0 time = 780
* CHECK dout0_17 vdout0_17ck155 = 0 time = 780
* CHECK dout0_18 vdout0_18ck155 = 1.1 time = 780
* CHECK dout0_19 vdout0_19ck155 = 1.1 time = 780
* CHECK dout0_20 vdout0_20ck155 = 1.1 time = 780
* CHECK dout0_21 vdout0_21ck155 = 1.1 time = 780
* CHECK dout0_22 vdout0_22ck155 = 1.1 time = 780
* CHECK dout0_23 vdout0_23ck155 = 1.1 time = 780
* CHECK dout0_24 vdout0_24ck155 = 1.1 time = 780
* CHECK dout0_25 vdout0_25ck155 = 0 time = 780
* CHECK dout0_26 vdout0_26ck155 = 1.1 time = 780
* CHECK dout0_27 vdout0_27ck155 = 1.1 time = 780
* CHECK dout0_28 vdout0_28ck155 = 1.1 time = 780
* CHECK dout0_29 vdout0_29ck155 = 1.1 time = 780
* CHECK dout0_30 vdout0_30ck155 = 0 time = 780
* CHECK dout0_31 vdout0_31ck155 = 0 time = 780
* CHECK dout0_0 vdout0_0ck160 = 0 time = 805
* CHECK dout0_1 vdout0_1ck160 = 1.1 time = 805
* CHECK dout0_2 vdout0_2ck160 = 1.1 time = 805
* CHECK dout0_3 vdout0_3ck160 = 0 time = 805
* CHECK dout0_4 vdout0_4ck160 = 0 time = 805
* CHECK dout0_5 vdout0_5ck160 = 1.1 time = 805
* CHECK dout0_6 vdout0_6ck160 = 1.1 time = 805
* CHECK dout0_7 vdout0_7ck160 = 0 time = 805
* CHECK dout0_8 vdout0_8ck160 = 0 time = 805
* CHECK dout0_9 vdout0_9ck160 = 0 time = 805
* CHECK dout0_10 vdout0_10ck160 = 0 time = 805
* CHECK dout0_11 vdout0_11ck160 = 1.1 time = 805
* CHECK dout0_12 vdout0_12ck160 = 1.1 time = 805
* CHECK dout0_13 vdout0_13ck160 = 1.1 time = 805
* CHECK dout0_14 vdout0_14ck160 = 0 time = 805
* CHECK dout0_15 vdout0_15ck160 = 1.1 time = 805
* CHECK dout0_16 vdout0_16ck160 = 0 time = 805
* CHECK dout0_17 vdout0_17ck160 = 0 time = 805
* CHECK dout0_18 vdout0_18ck160 = 0 time = 805
* CHECK dout0_19 vdout0_19ck160 = 1.1 time = 805
* CHECK dout0_20 vdout0_20ck160 = 0 time = 805
* CHECK dout0_21 vdout0_21ck160 = 1.1 time = 805
* CHECK dout0_22 vdout0_22ck160 = 1.1 time = 805
* CHECK dout0_23 vdout0_23ck160 = 0 time = 805
* CHECK dout0_24 vdout0_24ck160 = 1.1 time = 805
* CHECK dout0_25 vdout0_25ck160 = 1.1 time = 805
* CHECK dout0_26 vdout0_26ck160 = 1.1 time = 805
* CHECK dout0_27 vdout0_27ck160 = 0 time = 805
* CHECK dout0_28 vdout0_28ck160 = 0 time = 805
* CHECK dout0_29 vdout0_29ck160 = 1.1 time = 805
* CHECK dout0_30 vdout0_30ck160 = 0 time = 805
* CHECK dout0_31 vdout0_31ck160 = 0 time = 805
* CHECK dout0_0 vdout0_0ck161 = 0 time = 810
* CHECK dout0_1 vdout0_1ck161 = 1.1 time = 810
* CHECK dout0_2 vdout0_2ck161 = 1.1 time = 810
* CHECK dout0_3 vdout0_3ck161 = 1.1 time = 810
* CHECK dout0_4 vdout0_4ck161 = 1.1 time = 810
* CHECK dout0_5 vdout0_5ck161 = 0 time = 810
* CHECK dout0_6 vdout0_6ck161 = 0 time = 810
* CHECK dout0_7 vdout0_7ck161 = 0 time = 810
* CHECK dout0_8 vdout0_8ck161 = 1.1 time = 810
* CHECK dout0_9 vdout0_9ck161 = 1.1 time = 810
* CHECK dout0_10 vdout0_10ck161 = 0 time = 810
* CHECK dout0_11 vdout0_11ck161 = 1.1 time = 810
* CHECK dout0_12 vdout0_12ck161 = 1.1 time = 810
* CHECK dout0_13 vdout0_13ck161 = 0 time = 810
* CHECK dout0_14 vdout0_14ck161 = 1.1 time = 810
* CHECK dout0_15 vdout0_15ck161 = 1.1 time = 810
* CHECK dout0_16 vdout0_16ck161 = 1.1 time = 810
* CHECK dout0_17 vdout0_17ck161 = 0 time = 810
* CHECK dout0_18 vdout0_18ck161 = 1.1 time = 810
* CHECK dout0_19 vdout0_19ck161 = 1.1 time = 810
* CHECK dout0_20 vdout0_20ck161 = 0 time = 810
* CHECK dout0_21 vdout0_21ck161 = 0 time = 810
* CHECK dout0_22 vdout0_22ck161 = 1.1 time = 810
* CHECK dout0_23 vdout0_23ck161 = 0 time = 810
* CHECK dout0_24 vdout0_24ck161 = 1.1 time = 810
* CHECK dout0_25 vdout0_25ck161 = 1.1 time = 810
* CHECK dout0_26 vdout0_26ck161 = 1.1 time = 810
* CHECK dout0_27 vdout0_27ck161 = 1.1 time = 810
* CHECK dout0_28 vdout0_28ck161 = 1.1 time = 810
* CHECK dout0_29 vdout0_29ck161 = 0 time = 810
* CHECK dout0_30 vdout0_30ck161 = 0 time = 810
* CHECK dout0_31 vdout0_31ck161 = 0 time = 810
* CHECK dout0_0 vdout0_0ck162 = 0 time = 815
* CHECK dout0_1 vdout0_1ck162 = 1.1 time = 815
* CHECK dout0_2 vdout0_2ck162 = 1.1 time = 815
* CHECK dout0_3 vdout0_3ck162 = 0 time = 815
* CHECK dout0_4 vdout0_4ck162 = 0 time = 815
* CHECK dout0_5 vdout0_5ck162 = 1.1 time = 815
* CHECK dout0_6 vdout0_6ck162 = 1.1 time = 815
* CHECK dout0_7 vdout0_7ck162 = 0 time = 815
* CHECK dout0_8 vdout0_8ck162 = 0 time = 815
* CHECK dout0_9 vdout0_9ck162 = 0 time = 815
* CHECK dout0_10 vdout0_10ck162 = 0 time = 815
* CHECK dout0_11 vdout0_11ck162 = 1.1 time = 815
* CHECK dout0_12 vdout0_12ck162 = 1.1 time = 815
* CHECK dout0_13 vdout0_13ck162 = 1.1 time = 815
* CHECK dout0_14 vdout0_14ck162 = 0 time = 815
* CHECK dout0_15 vdout0_15ck162 = 1.1 time = 815
* CHECK dout0_16 vdout0_16ck162 = 0 time = 815
* CHECK dout0_17 vdout0_17ck162 = 0 time = 815
* CHECK dout0_18 vdout0_18ck162 = 0 time = 815
* CHECK dout0_19 vdout0_19ck162 = 1.1 time = 815
* CHECK dout0_20 vdout0_20ck162 = 0 time = 815
* CHECK dout0_21 vdout0_21ck162 = 1.1 time = 815
* CHECK dout0_22 vdout0_22ck162 = 1.1 time = 815
* CHECK dout0_23 vdout0_23ck162 = 0 time = 815
* CHECK dout0_24 vdout0_24ck162 = 1.1 time = 815
* CHECK dout0_25 vdout0_25ck162 = 1.1 time = 815
* CHECK dout0_26 vdout0_26ck162 = 1.1 time = 815
* CHECK dout0_27 vdout0_27ck162 = 0 time = 815
* CHECK dout0_28 vdout0_28ck162 = 0 time = 815
* CHECK dout0_29 vdout0_29ck162 = 1.1 time = 815
* CHECK dout0_30 vdout0_30ck162 = 0 time = 815
* CHECK dout0_31 vdout0_31ck162 = 0 time = 815
* CHECK dout0_0 vdout0_0ck164 = 1.1 time = 825
* CHECK dout0_1 vdout0_1ck164 = 0 time = 825
* CHECK dout0_2 vdout0_2ck164 = 0 time = 825
* CHECK dout0_3 vdout0_3ck164 = 0 time = 825
* CHECK dout0_4 vdout0_4ck164 = 0 time = 825
* CHECK dout0_5 vdout0_5ck164 = 0 time = 825
* CHECK dout0_6 vdout0_6ck164 = 0 time = 825
* CHECK dout0_7 vdout0_7ck164 = 1.1 time = 825
* CHECK dout0_8 vdout0_8ck164 = 1.1 time = 825
* CHECK dout0_9 vdout0_9ck164 = 1.1 time = 825
* CHECK dout0_10 vdout0_10ck164 = 1.1 time = 825
* CHECK dout0_11 vdout0_11ck164 = 1.1 time = 825
* CHECK dout0_12 vdout0_12ck164 = 1.1 time = 825
* CHECK dout0_13 vdout0_13ck164 = 1.1 time = 825
* CHECK dout0_14 vdout0_14ck164 = 1.1 time = 825
* CHECK dout0_15 vdout0_15ck164 = 1.1 time = 825
* CHECK dout0_16 vdout0_16ck164 = 0 time = 825
* CHECK dout0_17 vdout0_17ck164 = 1.1 time = 825
* CHECK dout0_18 vdout0_18ck164 = 1.1 time = 825
* CHECK dout0_19 vdout0_19ck164 = 1.1 time = 825
* CHECK dout0_20 vdout0_20ck164 = 0 time = 825
* CHECK dout0_21 vdout0_21ck164 = 1.1 time = 825
* CHECK dout0_22 vdout0_22ck164 = 0 time = 825
* CHECK dout0_23 vdout0_23ck164 = 1.1 time = 825
* CHECK dout0_24 vdout0_24ck164 = 0 time = 825
* CHECK dout0_25 vdout0_25ck164 = 1.1 time = 825
* CHECK dout0_26 vdout0_26ck164 = 0 time = 825
* CHECK dout0_27 vdout0_27ck164 = 0 time = 825
* CHECK dout0_28 vdout0_28ck164 = 1.1 time = 825
* CHECK dout0_29 vdout0_29ck164 = 1.1 time = 825
* CHECK dout0_30 vdout0_30ck164 = 0 time = 825
* CHECK dout0_31 vdout0_31ck164 = 0 time = 825
* CHECK dout0_0 vdout0_0ck165 = 1.1 time = 830
* CHECK dout0_1 vdout0_1ck165 = 0 time = 830
* CHECK dout0_2 vdout0_2ck165 = 0 time = 830
* CHECK dout0_3 vdout0_3ck165 = 0 time = 830
* CHECK dout0_4 vdout0_4ck165 = 0 time = 830
* CHECK dout0_5 vdout0_5ck165 = 0 time = 830
* CHECK dout0_6 vdout0_6ck165 = 0 time = 830
* CHECK dout0_7 vdout0_7ck165 = 1.1 time = 830
* CHECK dout0_8 vdout0_8ck165 = 1.1 time = 830
* CHECK dout0_9 vdout0_9ck165 = 1.1 time = 830
* CHECK dout0_10 vdout0_10ck165 = 1.1 time = 830
* CHECK dout0_11 vdout0_11ck165 = 1.1 time = 830
* CHECK dout0_12 vdout0_12ck165 = 1.1 time = 830
* CHECK dout0_13 vdout0_13ck165 = 1.1 time = 830
* CHECK dout0_14 vdout0_14ck165 = 1.1 time = 830
* CHECK dout0_15 vdout0_15ck165 = 1.1 time = 830
* CHECK dout0_16 vdout0_16ck165 = 0 time = 830
* CHECK dout0_17 vdout0_17ck165 = 1.1 time = 830
* CHECK dout0_18 vdout0_18ck165 = 1.1 time = 830
* CHECK dout0_19 vdout0_19ck165 = 1.1 time = 830
* CHECK dout0_20 vdout0_20ck165 = 0 time = 830
* CHECK dout0_21 vdout0_21ck165 = 1.1 time = 830
* CHECK dout0_22 vdout0_22ck165 = 0 time = 830
* CHECK dout0_23 vdout0_23ck165 = 1.1 time = 830
* CHECK dout0_24 vdout0_24ck165 = 0 time = 830
* CHECK dout0_25 vdout0_25ck165 = 1.1 time = 830
* CHECK dout0_26 vdout0_26ck165 = 0 time = 830
* CHECK dout0_27 vdout0_27ck165 = 0 time = 830
* CHECK dout0_28 vdout0_28ck165 = 1.1 time = 830
* CHECK dout0_29 vdout0_29ck165 = 1.1 time = 830
* CHECK dout0_30 vdout0_30ck165 = 0 time = 830
* CHECK dout0_31 vdout0_31ck165 = 0 time = 830
* CHECK dout0_0 vdout0_0ck166 = 0 time = 835
* CHECK dout0_1 vdout0_1ck166 = 1.1 time = 835
* CHECK dout0_2 vdout0_2ck166 = 1.1 time = 835
* CHECK dout0_3 vdout0_3ck166 = 0 time = 835
* CHECK dout0_4 vdout0_4ck166 = 0 time = 835
* CHECK dout0_5 vdout0_5ck166 = 1.1 time = 835
* CHECK dout0_6 vdout0_6ck166 = 1.1 time = 835
* CHECK dout0_7 vdout0_7ck166 = 0 time = 835
* CHECK dout0_8 vdout0_8ck166 = 0 time = 835
* CHECK dout0_9 vdout0_9ck166 = 0 time = 835
* CHECK dout0_10 vdout0_10ck166 = 0 time = 835
* CHECK dout0_11 vdout0_11ck166 = 1.1 time = 835
* CHECK dout0_12 vdout0_12ck166 = 1.1 time = 835
* CHECK dout0_13 vdout0_13ck166 = 1.1 time = 835
* CHECK dout0_14 vdout0_14ck166 = 0 time = 835
* CHECK dout0_15 vdout0_15ck166 = 1.1 time = 835
* CHECK dout0_16 vdout0_16ck166 = 0 time = 835
* CHECK dout0_17 vdout0_17ck166 = 0 time = 835
* CHECK dout0_18 vdout0_18ck166 = 0 time = 835
* CHECK dout0_19 vdout0_19ck166 = 1.1 time = 835
* CHECK dout0_20 vdout0_20ck166 = 0 time = 835
* CHECK dout0_21 vdout0_21ck166 = 1.1 time = 835
* CHECK dout0_22 vdout0_22ck166 = 1.1 time = 835
* CHECK dout0_23 vdout0_23ck166 = 0 time = 835
* CHECK dout0_24 vdout0_24ck166 = 1.1 time = 835
* CHECK dout0_25 vdout0_25ck166 = 1.1 time = 835
* CHECK dout0_26 vdout0_26ck166 = 1.1 time = 835
* CHECK dout0_27 vdout0_27ck166 = 0 time = 835
* CHECK dout0_28 vdout0_28ck166 = 0 time = 835
* CHECK dout0_29 vdout0_29ck166 = 1.1 time = 835
* CHECK dout0_30 vdout0_30ck166 = 0 time = 835
* CHECK dout0_31 vdout0_31ck166 = 0 time = 835
* CHECK dout0_0 vdout0_0ck167 = 1.1 time = 840
* CHECK dout0_1 vdout0_1ck167 = 0 time = 840
* CHECK dout0_2 vdout0_2ck167 = 1.1 time = 840
* CHECK dout0_3 vdout0_3ck167 = 1.1 time = 840
* CHECK dout0_4 vdout0_4ck167 = 0 time = 840
* CHECK dout0_5 vdout0_5ck167 = 1.1 time = 840
* CHECK dout0_6 vdout0_6ck167 = 1.1 time = 840
* CHECK dout0_7 vdout0_7ck167 = 1.1 time = 840
* CHECK dout0_8 vdout0_8ck167 = 1.1 time = 840
* CHECK dout0_9 vdout0_9ck167 = 1.1 time = 840
* CHECK dout0_10 vdout0_10ck167 = 1.1 time = 840
* CHECK dout0_11 vdout0_11ck167 = 0 time = 840
* CHECK dout0_12 vdout0_12ck167 = 0 time = 840
* CHECK dout0_13 vdout0_13ck167 = 1.1 time = 840
* CHECK dout0_14 vdout0_14ck167 = 1.1 time = 840
* CHECK dout0_15 vdout0_15ck167 = 1.1 time = 840
* CHECK dout0_16 vdout0_16ck167 = 1.1 time = 840
* CHECK dout0_17 vdout0_17ck167 = 1.1 time = 840
* CHECK dout0_18 vdout0_18ck167 = 1.1 time = 840
* CHECK dout0_19 vdout0_19ck167 = 1.1 time = 840
* CHECK dout0_20 vdout0_20ck167 = 0 time = 840
* CHECK dout0_21 vdout0_21ck167 = 1.1 time = 840
* CHECK dout0_22 vdout0_22ck167 = 1.1 time = 840
* CHECK dout0_23 vdout0_23ck167 = 1.1 time = 840
* CHECK dout0_24 vdout0_24ck167 = 0 time = 840
* CHECK dout0_25 vdout0_25ck167 = 0 time = 840
* CHECK dout0_26 vdout0_26ck167 = 0 time = 840
* CHECK dout0_27 vdout0_27ck167 = 0 time = 840
* CHECK dout0_28 vdout0_28ck167 = 0 time = 840
* CHECK dout0_29 vdout0_29ck167 = 0 time = 840
* CHECK dout0_30 vdout0_30ck167 = 0 time = 840
* CHECK dout0_31 vdout0_31ck167 = 0 time = 840
* CHECK dout0_0 vdout0_0ck170 = 0 time = 855
* CHECK dout0_1 vdout0_1ck170 = 0 time = 855
* CHECK dout0_2 vdout0_2ck170 = 1.1 time = 855
* CHECK dout0_3 vdout0_3ck170 = 1.1 time = 855
* CHECK dout0_4 vdout0_4ck170 = 0 time = 855
* CHECK dout0_5 vdout0_5ck170 = 0 time = 855
* CHECK dout0_6 vdout0_6ck170 = 1.1 time = 855
* CHECK dout0_7 vdout0_7ck170 = 1.1 time = 855
* CHECK dout0_8 vdout0_8ck170 = 1.1 time = 855
* CHECK dout0_9 vdout0_9ck170 = 1.1 time = 855
* CHECK dout0_10 vdout0_10ck170 = 0 time = 855
* CHECK dout0_11 vdout0_11ck170 = 0 time = 855
* CHECK dout0_12 vdout0_12ck170 = 1.1 time = 855
* CHECK dout0_13 vdout0_13ck170 = 1.1 time = 855
* CHECK dout0_14 vdout0_14ck170 = 1.1 time = 855
* CHECK dout0_15 vdout0_15ck170 = 1.1 time = 855
* CHECK dout0_16 vdout0_16ck170 = 0 time = 855
* CHECK dout0_17 vdout0_17ck170 = 1.1 time = 855
* CHECK dout0_18 vdout0_18ck170 = 1.1 time = 855
* CHECK dout0_19 vdout0_19ck170 = 0 time = 855
* CHECK dout0_20 vdout0_20ck170 = 1.1 time = 855
* CHECK dout0_21 vdout0_21ck170 = 0 time = 855
* CHECK dout0_22 vdout0_22ck170 = 1.1 time = 855
* CHECK dout0_23 vdout0_23ck170 = 1.1 time = 855
* CHECK dout0_24 vdout0_24ck170 = 0 time = 855
* CHECK dout0_25 vdout0_25ck170 = 0 time = 855
* CHECK dout0_26 vdout0_26ck170 = 1.1 time = 855
* CHECK dout0_27 vdout0_27ck170 = 0 time = 855
* CHECK dout0_28 vdout0_28ck170 = 1.1 time = 855
* CHECK dout0_29 vdout0_29ck170 = 1.1 time = 855
* CHECK dout0_30 vdout0_30ck170 = 0 time = 855
* CHECK dout0_31 vdout0_31ck170 = 1.1 time = 855
* CHECK dout0_0 vdout0_0ck171 = 1.1 time = 860
* CHECK dout0_1 vdout0_1ck171 = 0 time = 860
* CHECK dout0_2 vdout0_2ck171 = 1.1 time = 860
* CHECK dout0_3 vdout0_3ck171 = 0 time = 860
* CHECK dout0_4 vdout0_4ck171 = 0 time = 860
* CHECK dout0_5 vdout0_5ck171 = 1.1 time = 860
* CHECK dout0_6 vdout0_6ck171 = 0 time = 860
* CHECK dout0_7 vdout0_7ck171 = 0 time = 860
* CHECK dout0_8 vdout0_8ck171 = 0 time = 860
* CHECK dout0_9 vdout0_9ck171 = 1.1 time = 860
* CHECK dout0_10 vdout0_10ck171 = 1.1 time = 860
* CHECK dout0_11 vdout0_11ck171 = 1.1 time = 860
* CHECK dout0_12 vdout0_12ck171 = 0 time = 860
* CHECK dout0_13 vdout0_13ck171 = 1.1 time = 860
* CHECK dout0_14 vdout0_14ck171 = 1.1 time = 860
* CHECK dout0_15 vdout0_15ck171 = 0 time = 860
* CHECK dout0_16 vdout0_16ck171 = 0 time = 860
* CHECK dout0_17 vdout0_17ck171 = 1.1 time = 860
* CHECK dout0_18 vdout0_18ck171 = 0 time = 860
* CHECK dout0_19 vdout0_19ck171 = 1.1 time = 860
* CHECK dout0_20 vdout0_20ck171 = 0 time = 860
* CHECK dout0_21 vdout0_21ck171 = 1.1 time = 860
* CHECK dout0_22 vdout0_22ck171 = 0 time = 860
* CHECK dout0_23 vdout0_23ck171 = 0 time = 860
* CHECK dout0_24 vdout0_24ck171 = 1.1 time = 860
* CHECK dout0_25 vdout0_25ck171 = 1.1 time = 860
* CHECK dout0_26 vdout0_26ck171 = 1.1 time = 860
* CHECK dout0_27 vdout0_27ck171 = 1.1 time = 860
* CHECK dout0_28 vdout0_28ck171 = 1.1 time = 860
* CHECK dout0_29 vdout0_29ck171 = 0 time = 860
* CHECK dout0_30 vdout0_30ck171 = 0 time = 860
* CHECK dout0_31 vdout0_31ck171 = 1.1 time = 860
* CHECK dout0_0 vdout0_0ck177 = 0 time = 890
* CHECK dout0_1 vdout0_1ck177 = 0 time = 890
* CHECK dout0_2 vdout0_2ck177 = 1.1 time = 890
* CHECK dout0_3 vdout0_3ck177 = 1.1 time = 890
* CHECK dout0_4 vdout0_4ck177 = 0 time = 890
* CHECK dout0_5 vdout0_5ck177 = 0 time = 890
* CHECK dout0_6 vdout0_6ck177 = 1.1 time = 890
* CHECK dout0_7 vdout0_7ck177 = 1.1 time = 890
* CHECK dout0_8 vdout0_8ck177 = 1.1 time = 890
* CHECK dout0_9 vdout0_9ck177 = 1.1 time = 890
* CHECK dout0_10 vdout0_10ck177 = 0 time = 890
* CHECK dout0_11 vdout0_11ck177 = 0 time = 890
* CHECK dout0_12 vdout0_12ck177 = 1.1 time = 890
* CHECK dout0_13 vdout0_13ck177 = 1.1 time = 890
* CHECK dout0_14 vdout0_14ck177 = 1.1 time = 890
* CHECK dout0_15 vdout0_15ck177 = 1.1 time = 890
* CHECK dout0_16 vdout0_16ck177 = 0 time = 890
* CHECK dout0_17 vdout0_17ck177 = 1.1 time = 890
* CHECK dout0_18 vdout0_18ck177 = 1.1 time = 890
* CHECK dout0_19 vdout0_19ck177 = 0 time = 890
* CHECK dout0_20 vdout0_20ck177 = 1.1 time = 890
* CHECK dout0_21 vdout0_21ck177 = 0 time = 890
* CHECK dout0_22 vdout0_22ck177 = 1.1 time = 890
* CHECK dout0_23 vdout0_23ck177 = 1.1 time = 890
* CHECK dout0_24 vdout0_24ck177 = 0 time = 890
* CHECK dout0_25 vdout0_25ck177 = 0 time = 890
* CHECK dout0_26 vdout0_26ck177 = 1.1 time = 890
* CHECK dout0_27 vdout0_27ck177 = 0 time = 890
* CHECK dout0_28 vdout0_28ck177 = 1.1 time = 890
* CHECK dout0_29 vdout0_29ck177 = 1.1 time = 890
* CHECK dout0_30 vdout0_30ck177 = 0 time = 890
* CHECK dout0_31 vdout0_31ck177 = 1.1 time = 890
* CHECK dout0_0 vdout0_0ck179 = 0 time = 900
* CHECK dout0_1 vdout0_1ck179 = 1.1 time = 900
* CHECK dout0_2 vdout0_2ck179 = 1.1 time = 900
* CHECK dout0_3 vdout0_3ck179 = 0 time = 900
* CHECK dout0_4 vdout0_4ck179 = 0 time = 900
* CHECK dout0_5 vdout0_5ck179 = 1.1 time = 900
* CHECK dout0_6 vdout0_6ck179 = 1.1 time = 900
* CHECK dout0_7 vdout0_7ck179 = 0 time = 900
* CHECK dout0_8 vdout0_8ck179 = 0 time = 900
* CHECK dout0_9 vdout0_9ck179 = 0 time = 900
* CHECK dout0_10 vdout0_10ck179 = 0 time = 900
* CHECK dout0_11 vdout0_11ck179 = 1.1 time = 900
* CHECK dout0_12 vdout0_12ck179 = 1.1 time = 900
* CHECK dout0_13 vdout0_13ck179 = 1.1 time = 900
* CHECK dout0_14 vdout0_14ck179 = 0 time = 900
* CHECK dout0_15 vdout0_15ck179 = 1.1 time = 900
* CHECK dout0_16 vdout0_16ck179 = 0 time = 900
* CHECK dout0_17 vdout0_17ck179 = 0 time = 900
* CHECK dout0_18 vdout0_18ck179 = 0 time = 900
* CHECK dout0_19 vdout0_19ck179 = 1.1 time = 900
* CHECK dout0_20 vdout0_20ck179 = 0 time = 900
* CHECK dout0_21 vdout0_21ck179 = 1.1 time = 900
* CHECK dout0_22 vdout0_22ck179 = 1.1 time = 900
* CHECK dout0_23 vdout0_23ck179 = 0 time = 900
* CHECK dout0_24 vdout0_24ck179 = 1.1 time = 900
* CHECK dout0_25 vdout0_25ck179 = 1.1 time = 900
* CHECK dout0_26 vdout0_26ck179 = 1.1 time = 900
* CHECK dout0_27 vdout0_27ck179 = 0 time = 900
* CHECK dout0_28 vdout0_28ck179 = 0 time = 900
* CHECK dout0_29 vdout0_29ck179 = 1.1 time = 900
* CHECK dout0_30 vdout0_30ck179 = 0 time = 900
* CHECK dout0_31 vdout0_31ck179 = 0 time = 900
* CHECK dout0_0 vdout0_0ck184 = 0 time = 925
* CHECK dout0_1 vdout0_1ck184 = 0 time = 925
* CHECK dout0_2 vdout0_2ck184 = 0 time = 925
* CHECK dout0_3 vdout0_3ck184 = 0 time = 925
* CHECK dout0_4 vdout0_4ck184 = 1.1 time = 925
* CHECK dout0_5 vdout0_5ck184 = 1.1 time = 925
* CHECK dout0_6 vdout0_6ck184 = 1.1 time = 925
* CHECK dout0_7 vdout0_7ck184 = 1.1 time = 925
* CHECK dout0_8 vdout0_8ck184 = 1.1 time = 925
* CHECK dout0_9 vdout0_9ck184 = 1.1 time = 925
* CHECK dout0_10 vdout0_10ck184 = 0 time = 925
* CHECK dout0_11 vdout0_11ck184 = 0 time = 925
* CHECK dout0_12 vdout0_12ck184 = 1.1 time = 925
* CHECK dout0_13 vdout0_13ck184 = 1.1 time = 925
* CHECK dout0_14 vdout0_14ck184 = 1.1 time = 925
* CHECK dout0_15 vdout0_15ck184 = 1.1 time = 925
* CHECK dout0_16 vdout0_16ck184 = 0 time = 925
* CHECK dout0_17 vdout0_17ck184 = 1.1 time = 925
* CHECK dout0_18 vdout0_18ck184 = 1.1 time = 925
* CHECK dout0_19 vdout0_19ck184 = 0 time = 925
* CHECK dout0_20 vdout0_20ck184 = 1.1 time = 925
* CHECK dout0_21 vdout0_21ck184 = 0 time = 925
* CHECK dout0_22 vdout0_22ck184 = 0 time = 925
* CHECK dout0_23 vdout0_23ck184 = 0 time = 925
* CHECK dout0_24 vdout0_24ck184 = 0 time = 925
* CHECK dout0_25 vdout0_25ck184 = 0 time = 925
* CHECK dout0_26 vdout0_26ck184 = 1.1 time = 925
* CHECK dout0_27 vdout0_27ck184 = 1.1 time = 925
* CHECK dout0_28 vdout0_28ck184 = 1.1 time = 925
* CHECK dout0_29 vdout0_29ck184 = 0 time = 925
* CHECK dout0_30 vdout0_30ck184 = 1.1 time = 925
* CHECK dout0_31 vdout0_31ck184 = 0 time = 925
* CHECK dout0_0 vdout0_0ck186 = 0 time = 935
* CHECK dout0_1 vdout0_1ck186 = 0 time = 935
* CHECK dout0_2 vdout0_2ck186 = 0 time = 935
* CHECK dout0_3 vdout0_3ck186 = 1.1 time = 935
* CHECK dout0_4 vdout0_4ck186 = 0 time = 935
* CHECK dout0_5 vdout0_5ck186 = 1.1 time = 935
* CHECK dout0_6 vdout0_6ck186 = 0 time = 935
* CHECK dout0_7 vdout0_7ck186 = 0 time = 935
* CHECK dout0_8 vdout0_8ck186 = 1.1 time = 935
* CHECK dout0_9 vdout0_9ck186 = 0 time = 935
* CHECK dout0_10 vdout0_10ck186 = 1.1 time = 935
* CHECK dout0_11 vdout0_11ck186 = 1.1 time = 935
* CHECK dout0_12 vdout0_12ck186 = 1.1 time = 935
* CHECK dout0_13 vdout0_13ck186 = 0 time = 935
* CHECK dout0_14 vdout0_14ck186 = 0 time = 935
* CHECK dout0_15 vdout0_15ck186 = 1.1 time = 935
* CHECK dout0_16 vdout0_16ck186 = 0 time = 935
* CHECK dout0_17 vdout0_17ck186 = 0 time = 935
* CHECK dout0_18 vdout0_18ck186 = 0 time = 935
* CHECK dout0_19 vdout0_19ck186 = 0 time = 935
* CHECK dout0_20 vdout0_20ck186 = 1.1 time = 935
* CHECK dout0_21 vdout0_21ck186 = 1.1 time = 935
* CHECK dout0_22 vdout0_22ck186 = 1.1 time = 935
* CHECK dout0_23 vdout0_23ck186 = 0 time = 935
* CHECK dout0_24 vdout0_24ck186 = 1.1 time = 935
* CHECK dout0_25 vdout0_25ck186 = 1.1 time = 935
* CHECK dout0_26 vdout0_26ck186 = 1.1 time = 935
* CHECK dout0_27 vdout0_27ck186 = 0 time = 935
* CHECK dout0_28 vdout0_28ck186 = 0 time = 935
* CHECK dout0_29 vdout0_29ck186 = 0 time = 935
* CHECK dout0_30 vdout0_30ck186 = 1.1 time = 935
* CHECK dout0_31 vdout0_31ck186 = 0 time = 935
* CHECK dout0_0 vdout0_0ck187 = 1.1 time = 940
* CHECK dout0_1 vdout0_1ck187 = 0 time = 940
* CHECK dout0_2 vdout0_2ck187 = 1.1 time = 940
* CHECK dout0_3 vdout0_3ck187 = 0 time = 940
* CHECK dout0_4 vdout0_4ck187 = 0 time = 940
* CHECK dout0_5 vdout0_5ck187 = 1.1 time = 940
* CHECK dout0_6 vdout0_6ck187 = 0 time = 940
* CHECK dout0_7 vdout0_7ck187 = 1.1 time = 940
* CHECK dout0_8 vdout0_8ck187 = 1.1 time = 940
* CHECK dout0_9 vdout0_9ck187 = 0 time = 940
* CHECK dout0_10 vdout0_10ck187 = 0 time = 940
* CHECK dout0_11 vdout0_11ck187 = 0 time = 940
* CHECK dout0_12 vdout0_12ck187 = 0 time = 940
* CHECK dout0_13 vdout0_13ck187 = 1.1 time = 940
* CHECK dout0_14 vdout0_14ck187 = 0 time = 940
* CHECK dout0_15 vdout0_15ck187 = 0 time = 940
* CHECK dout0_16 vdout0_16ck187 = 0 time = 940
* CHECK dout0_17 vdout0_17ck187 = 1.1 time = 940
* CHECK dout0_18 vdout0_18ck187 = 0 time = 940
* CHECK dout0_19 vdout0_19ck187 = 0 time = 940
* CHECK dout0_20 vdout0_20ck187 = 1.1 time = 940
* CHECK dout0_21 vdout0_21ck187 = 0 time = 940
* CHECK dout0_22 vdout0_22ck187 = 1.1 time = 940
* CHECK dout0_23 vdout0_23ck187 = 1.1 time = 940
* CHECK dout0_24 vdout0_24ck187 = 0 time = 940
* CHECK dout0_25 vdout0_25ck187 = 1.1 time = 940
* CHECK dout0_26 vdout0_26ck187 = 1.1 time = 940
* CHECK dout0_27 vdout0_27ck187 = 1.1 time = 940
* CHECK dout0_28 vdout0_28ck187 = 1.1 time = 940
* CHECK dout0_29 vdout0_29ck187 = 0 time = 940
* CHECK dout0_30 vdout0_30ck187 = 1.1 time = 940
* CHECK dout0_31 vdout0_31ck187 = 0 time = 940
* CHECK dout0_0 vdout0_0ck188 = 0 time = 945
* CHECK dout0_1 vdout0_1ck188 = 0 time = 945
* CHECK dout0_2 vdout0_2ck188 = 0 time = 945
* CHECK dout0_3 vdout0_3ck188 = 1.1 time = 945
* CHECK dout0_4 vdout0_4ck188 = 0 time = 945
* CHECK dout0_5 vdout0_5ck188 = 1.1 time = 945
* CHECK dout0_6 vdout0_6ck188 = 0 time = 945
* CHECK dout0_7 vdout0_7ck188 = 0 time = 945
* CHECK dout0_8 vdout0_8ck188 = 1.1 time = 945
* CHECK dout0_9 vdout0_9ck188 = 0 time = 945
* CHECK dout0_10 vdout0_10ck188 = 1.1 time = 945
* CHECK dout0_11 vdout0_11ck188 = 1.1 time = 945
* CHECK dout0_12 vdout0_12ck188 = 1.1 time = 945
* CHECK dout0_13 vdout0_13ck188 = 0 time = 945
* CHECK dout0_14 vdout0_14ck188 = 0 time = 945
* CHECK dout0_15 vdout0_15ck188 = 1.1 time = 945
* CHECK dout0_16 vdout0_16ck188 = 0 time = 945
* CHECK dout0_17 vdout0_17ck188 = 0 time = 945
* CHECK dout0_18 vdout0_18ck188 = 0 time = 945
* CHECK dout0_19 vdout0_19ck188 = 0 time = 945
* CHECK dout0_20 vdout0_20ck188 = 1.1 time = 945
* CHECK dout0_21 vdout0_21ck188 = 1.1 time = 945
* CHECK dout0_22 vdout0_22ck188 = 1.1 time = 945
* CHECK dout0_23 vdout0_23ck188 = 0 time = 945
* CHECK dout0_24 vdout0_24ck188 = 1.1 time = 945
* CHECK dout0_25 vdout0_25ck188 = 1.1 time = 945
* CHECK dout0_26 vdout0_26ck188 = 1.1 time = 945
* CHECK dout0_27 vdout0_27ck188 = 0 time = 945
* CHECK dout0_28 vdout0_28ck188 = 0 time = 945
* CHECK dout0_29 vdout0_29ck188 = 0 time = 945
* CHECK dout0_30 vdout0_30ck188 = 1.1 time = 945
* CHECK dout0_31 vdout0_31ck188 = 0 time = 945
* CHECK dout0_0 vdout0_0ck192 = 1.1 time = 965
* CHECK dout0_1 vdout0_1ck192 = 0 time = 965
* CHECK dout0_2 vdout0_2ck192 = 0 time = 965
* CHECK dout0_3 vdout0_3ck192 = 1.1 time = 965
* CHECK dout0_4 vdout0_4ck192 = 1.1 time = 965
* CHECK dout0_5 vdout0_5ck192 = 1.1 time = 965
* CHECK dout0_6 vdout0_6ck192 = 1.1 time = 965
* CHECK dout0_7 vdout0_7ck192 = 1.1 time = 965
* CHECK dout0_8 vdout0_8ck192 = 0 time = 965
* CHECK dout0_9 vdout0_9ck192 = 1.1 time = 965
* CHECK dout0_10 vdout0_10ck192 = 1.1 time = 965
* CHECK dout0_11 vdout0_11ck192 = 0 time = 965
* CHECK dout0_12 vdout0_12ck192 = 1.1 time = 965
* CHECK dout0_13 vdout0_13ck192 = 0 time = 965
* CHECK dout0_14 vdout0_14ck192 = 0 time = 965
* CHECK dout0_15 vdout0_15ck192 = 1.1 time = 965
* CHECK dout0_16 vdout0_16ck192 = 1.1 time = 965
* CHECK dout0_17 vdout0_17ck192 = 0 time = 965
* CHECK dout0_18 vdout0_18ck192 = 0 time = 965
* CHECK dout0_19 vdout0_19ck192 = 1.1 time = 965
* CHECK dout0_20 vdout0_20ck192 = 0 time = 965
* CHECK dout0_21 vdout0_21ck192 = 1.1 time = 965
* CHECK dout0_22 vdout0_22ck192 = 1.1 time = 965
* CHECK dout0_23 vdout0_23ck192 = 1.1 time = 965
* CHECK dout0_24 vdout0_24ck192 = 1.1 time = 965
* CHECK dout0_25 vdout0_25ck192 = 1.1 time = 965
* CHECK dout0_26 vdout0_26ck192 = 1.1 time = 965
* CHECK dout0_27 vdout0_27ck192 = 1.1 time = 965
* CHECK dout0_28 vdout0_28ck192 = 1.1 time = 965
* CHECK dout0_29 vdout0_29ck192 = 1.1 time = 965
* CHECK dout0_30 vdout0_30ck192 = 0 time = 965
* CHECK dout0_31 vdout0_31ck192 = 0 time = 965
* CHECK dout0_0 vdout0_0ck193 = 0 time = 970
* CHECK dout0_1 vdout0_1ck193 = 0 time = 970
* CHECK dout0_2 vdout0_2ck193 = 0 time = 970
* CHECK dout0_3 vdout0_3ck193 = 0 time = 970
* CHECK dout0_4 vdout0_4ck193 = 1.1 time = 970
* CHECK dout0_5 vdout0_5ck193 = 1.1 time = 970
* CHECK dout0_6 vdout0_6ck193 = 1.1 time = 970
* CHECK dout0_7 vdout0_7ck193 = 1.1 time = 970
* CHECK dout0_8 vdout0_8ck193 = 1.1 time = 970
* CHECK dout0_9 vdout0_9ck193 = 1.1 time = 970
* CHECK dout0_10 vdout0_10ck193 = 0 time = 970
* CHECK dout0_11 vdout0_11ck193 = 0 time = 970
* CHECK dout0_12 vdout0_12ck193 = 1.1 time = 970
* CHECK dout0_13 vdout0_13ck193 = 1.1 time = 970
* CHECK dout0_14 vdout0_14ck193 = 1.1 time = 970
* CHECK dout0_15 vdout0_15ck193 = 1.1 time = 970
* CHECK dout0_16 vdout0_16ck193 = 0 time = 970
* CHECK dout0_17 vdout0_17ck193 = 1.1 time = 970
* CHECK dout0_18 vdout0_18ck193 = 1.1 time = 970
* CHECK dout0_19 vdout0_19ck193 = 0 time = 970
* CHECK dout0_20 vdout0_20ck193 = 1.1 time = 970
* CHECK dout0_21 vdout0_21ck193 = 0 time = 970
* CHECK dout0_22 vdout0_22ck193 = 0 time = 970
* CHECK dout0_23 vdout0_23ck193 = 0 time = 970
* CHECK dout0_24 vdout0_24ck193 = 0 time = 970
* CHECK dout0_25 vdout0_25ck193 = 0 time = 970
* CHECK dout0_26 vdout0_26ck193 = 1.1 time = 970
* CHECK dout0_27 vdout0_27ck193 = 1.1 time = 970
* CHECK dout0_28 vdout0_28ck193 = 1.1 time = 970
* CHECK dout0_29 vdout0_29ck193 = 0 time = 970
* CHECK dout0_30 vdout0_30ck193 = 1.1 time = 970
* CHECK dout0_31 vdout0_31ck193 = 0 time = 970
* CHECK dout0_0 vdout0_0ck202 = 0 time = 1015
* CHECK dout0_1 vdout0_1ck202 = 0 time = 1015
* CHECK dout0_2 vdout0_2ck202 = 1.1 time = 1015
* CHECK dout0_3 vdout0_3ck202 = 0 time = 1015
* CHECK dout0_4 vdout0_4ck202 = 1.1 time = 1015
* CHECK dout0_5 vdout0_5ck202 = 1.1 time = 1015
* CHECK dout0_6 vdout0_6ck202 = 1.1 time = 1015
* CHECK dout0_7 vdout0_7ck202 = 1.1 time = 1015
* CHECK dout0_8 vdout0_8ck202 = 1.1 time = 1015
* CHECK dout0_9 vdout0_9ck202 = 0 time = 1015
* CHECK dout0_10 vdout0_10ck202 = 1.1 time = 1015
* CHECK dout0_11 vdout0_11ck202 = 0 time = 1015
* CHECK dout0_12 vdout0_12ck202 = 0 time = 1015
* CHECK dout0_13 vdout0_13ck202 = 0 time = 1015
* CHECK dout0_14 vdout0_14ck202 = 1.1 time = 1015
* CHECK dout0_15 vdout0_15ck202 = 1.1 time = 1015
* CHECK dout0_16 vdout0_16ck202 = 0 time = 1015
* CHECK dout0_17 vdout0_17ck202 = 0 time = 1015
* CHECK dout0_18 vdout0_18ck202 = 0 time = 1015
* CHECK dout0_19 vdout0_19ck202 = 1.1 time = 1015
* CHECK dout0_20 vdout0_20ck202 = 0 time = 1015
* CHECK dout0_21 vdout0_21ck202 = 0 time = 1015
* CHECK dout0_22 vdout0_22ck202 = 0 time = 1015
* CHECK dout0_23 vdout0_23ck202 = 1.1 time = 1015
* CHECK dout0_24 vdout0_24ck202 = 0 time = 1015
* CHECK dout0_25 vdout0_25ck202 = 0 time = 1015
* CHECK dout0_26 vdout0_26ck202 = 0 time = 1015
* CHECK dout0_27 vdout0_27ck202 = 0 time = 1015
* CHECK dout0_28 vdout0_28ck202 = 0 time = 1015
* CHECK dout0_29 vdout0_29ck202 = 1.1 time = 1015
* CHECK dout0_30 vdout0_30ck202 = 1.1 time = 1015
* CHECK dout0_31 vdout0_31ck202 = 0 time = 1015
* CHECK dout0_0 vdout0_0ck204 = 0 time = 1025
* CHECK dout0_1 vdout0_1ck204 = 0 time = 1025
* CHECK dout0_2 vdout0_2ck204 = 0 time = 1025
* CHECK dout0_3 vdout0_3ck204 = 0 time = 1025
* CHECK dout0_4 vdout0_4ck204 = 1.1 time = 1025
* CHECK dout0_5 vdout0_5ck204 = 1.1 time = 1025
* CHECK dout0_6 vdout0_6ck204 = 1.1 time = 1025
* CHECK dout0_7 vdout0_7ck204 = 1.1 time = 1025
* CHECK dout0_8 vdout0_8ck204 = 1.1 time = 1025
* CHECK dout0_9 vdout0_9ck204 = 1.1 time = 1025
* CHECK dout0_10 vdout0_10ck204 = 0 time = 1025
* CHECK dout0_11 vdout0_11ck204 = 0 time = 1025
* CHECK dout0_12 vdout0_12ck204 = 1.1 time = 1025
* CHECK dout0_13 vdout0_13ck204 = 1.1 time = 1025
* CHECK dout0_14 vdout0_14ck204 = 1.1 time = 1025
* CHECK dout0_15 vdout0_15ck204 = 1.1 time = 1025
* CHECK dout0_16 vdout0_16ck204 = 0 time = 1025
* CHECK dout0_17 vdout0_17ck204 = 1.1 time = 1025
* CHECK dout0_18 vdout0_18ck204 = 1.1 time = 1025
* CHECK dout0_19 vdout0_19ck204 = 0 time = 1025
* CHECK dout0_20 vdout0_20ck204 = 1.1 time = 1025
* CHECK dout0_21 vdout0_21ck204 = 0 time = 1025
* CHECK dout0_22 vdout0_22ck204 = 0 time = 1025
* CHECK dout0_23 vdout0_23ck204 = 0 time = 1025
* CHECK dout0_24 vdout0_24ck204 = 0 time = 1025
* CHECK dout0_25 vdout0_25ck204 = 0 time = 1025
* CHECK dout0_26 vdout0_26ck204 = 1.1 time = 1025
* CHECK dout0_27 vdout0_27ck204 = 1.1 time = 1025
* CHECK dout0_28 vdout0_28ck204 = 1.1 time = 1025
* CHECK dout0_29 vdout0_29ck204 = 0 time = 1025
* CHECK dout0_30 vdout0_30ck204 = 1.1 time = 1025
* CHECK dout0_31 vdout0_31ck204 = 0 time = 1025
.include /home/ali/OpenRAM/projects/SRAM_32x64_1rw/functional_meas.sp
* probe is used for hspice/xa, while plot is used in ngspice
*.probe V(*)
*.plot V(*)
.end
