.meas tran vdout0_0ck40 FIND v(dout0_0) AT=25.025n

.meas tran vdout0_1ck40 FIND v(dout0_1) AT=25.025n

.meas tran vdout0_2ck40 FIND v(dout0_2) AT=25.025n

.meas tran vdout0_3ck40 FIND v(dout0_3) AT=25.025n

.meas tran vdout0_4ck40 FIND v(dout0_4) AT=25.025n

.meas tran vdout0_5ck40 FIND v(dout0_5) AT=25.025n

.meas tran vdout0_6ck40 FIND v(dout0_6) AT=25.025n

.meas tran vdout0_7ck40 FIND v(dout0_7) AT=25.025n

.meas tran vdout0_8ck40 FIND v(dout0_8) AT=25.025n

.meas tran vdout0_9ck40 FIND v(dout0_9) AT=25.025n

.meas tran vdout0_10ck40 FIND v(dout0_10) AT=25.025n

.meas tran vdout0_11ck40 FIND v(dout0_11) AT=25.025n

.meas tran vdout0_12ck40 FIND v(dout0_12) AT=25.025n

.meas tran vdout0_13ck40 FIND v(dout0_13) AT=25.025n

.meas tran vdout0_14ck40 FIND v(dout0_14) AT=25.025n

.meas tran vdout0_15ck40 FIND v(dout0_15) AT=25.025n

.meas tran vdout0_16ck40 FIND v(dout0_16) AT=25.025n

.meas tran vdout0_17ck40 FIND v(dout0_17) AT=25.025n

.meas tran vdout0_18ck40 FIND v(dout0_18) AT=25.025n

.meas tran vdout0_19ck40 FIND v(dout0_19) AT=25.025n

.meas tran vdout0_20ck40 FIND v(dout0_20) AT=25.025n

.meas tran vdout0_21ck40 FIND v(dout0_21) AT=25.025n

.meas tran vdout0_22ck40 FIND v(dout0_22) AT=25.025n

.meas tran vdout0_23ck40 FIND v(dout0_23) AT=25.025n

.meas tran vdout0_24ck40 FIND v(dout0_24) AT=25.025n

.meas tran vdout0_25ck40 FIND v(dout0_25) AT=25.025n

.meas tran vdout0_26ck40 FIND v(dout0_26) AT=25.025n

.meas tran vdout0_27ck40 FIND v(dout0_27) AT=25.025n

.meas tran vdout0_28ck40 FIND v(dout0_28) AT=25.025n

.meas tran vdout0_29ck40 FIND v(dout0_29) AT=25.025n

.meas tran vdout0_30ck40 FIND v(dout0_30) AT=25.025n

.meas tran vdout0_31ck40 FIND v(dout0_31) AT=25.025n

.meas tran vdout0_0ck50 FIND v(dout0_0) AT=30.025n

.meas tran vdout0_1ck50 FIND v(dout0_1) AT=30.025n

.meas tran vdout0_2ck50 FIND v(dout0_2) AT=30.025n

.meas tran vdout0_3ck50 FIND v(dout0_3) AT=30.025n

.meas tran vdout0_4ck50 FIND v(dout0_4) AT=30.025n

.meas tran vdout0_5ck50 FIND v(dout0_5) AT=30.025n

.meas tran vdout0_6ck50 FIND v(dout0_6) AT=30.025n

.meas tran vdout0_7ck50 FIND v(dout0_7) AT=30.025n

.meas tran vdout0_8ck50 FIND v(dout0_8) AT=30.025n

.meas tran vdout0_9ck50 FIND v(dout0_9) AT=30.025n

.meas tran vdout0_10ck50 FIND v(dout0_10) AT=30.025n

.meas tran vdout0_11ck50 FIND v(dout0_11) AT=30.025n

.meas tran vdout0_12ck50 FIND v(dout0_12) AT=30.025n

.meas tran vdout0_13ck50 FIND v(dout0_13) AT=30.025n

.meas tran vdout0_14ck50 FIND v(dout0_14) AT=30.025n

.meas tran vdout0_15ck50 FIND v(dout0_15) AT=30.025n

.meas tran vdout0_16ck50 FIND v(dout0_16) AT=30.025n

.meas tran vdout0_17ck50 FIND v(dout0_17) AT=30.025n

.meas tran vdout0_18ck50 FIND v(dout0_18) AT=30.025n

.meas tran vdout0_19ck50 FIND v(dout0_19) AT=30.025n

.meas tran vdout0_20ck50 FIND v(dout0_20) AT=30.025n

.meas tran vdout0_21ck50 FIND v(dout0_21) AT=30.025n

.meas tran vdout0_22ck50 FIND v(dout0_22) AT=30.025n

.meas tran vdout0_23ck50 FIND v(dout0_23) AT=30.025n

.meas tran vdout0_24ck50 FIND v(dout0_24) AT=30.025n

.meas tran vdout0_25ck50 FIND v(dout0_25) AT=30.025n

.meas tran vdout0_26ck50 FIND v(dout0_26) AT=30.025n

.meas tran vdout0_27ck50 FIND v(dout0_27) AT=30.025n

.meas tran vdout0_28ck50 FIND v(dout0_28) AT=30.025n

.meas tran vdout0_29ck50 FIND v(dout0_29) AT=30.025n

.meas tran vdout0_30ck50 FIND v(dout0_30) AT=30.025n

.meas tran vdout0_31ck50 FIND v(dout0_31) AT=30.025n

.meas tran vdout0_0ck90 FIND v(dout0_0) AT=50.025n

.meas tran vdout0_1ck90 FIND v(dout0_1) AT=50.025n

.meas tran vdout0_2ck90 FIND v(dout0_2) AT=50.025n

.meas tran vdout0_3ck90 FIND v(dout0_3) AT=50.025n

.meas tran vdout0_4ck90 FIND v(dout0_4) AT=50.025n

.meas tran vdout0_5ck90 FIND v(dout0_5) AT=50.025n

.meas tran vdout0_6ck90 FIND v(dout0_6) AT=50.025n

.meas tran vdout0_7ck90 FIND v(dout0_7) AT=50.025n

.meas tran vdout0_8ck90 FIND v(dout0_8) AT=50.025n

.meas tran vdout0_9ck90 FIND v(dout0_9) AT=50.025n

.meas tran vdout0_10ck90 FIND v(dout0_10) AT=50.025n

.meas tran vdout0_11ck90 FIND v(dout0_11) AT=50.025n

.meas tran vdout0_12ck90 FIND v(dout0_12) AT=50.025n

.meas tran vdout0_13ck90 FIND v(dout0_13) AT=50.025n

.meas tran vdout0_14ck90 FIND v(dout0_14) AT=50.025n

.meas tran vdout0_15ck90 FIND v(dout0_15) AT=50.025n

.meas tran vdout0_16ck90 FIND v(dout0_16) AT=50.025n

.meas tran vdout0_17ck90 FIND v(dout0_17) AT=50.025n

.meas tran vdout0_18ck90 FIND v(dout0_18) AT=50.025n

.meas tran vdout0_19ck90 FIND v(dout0_19) AT=50.025n

.meas tran vdout0_20ck90 FIND v(dout0_20) AT=50.025n

.meas tran vdout0_21ck90 FIND v(dout0_21) AT=50.025n

.meas tran vdout0_22ck90 FIND v(dout0_22) AT=50.025n

.meas tran vdout0_23ck90 FIND v(dout0_23) AT=50.025n

.meas tran vdout0_24ck90 FIND v(dout0_24) AT=50.025n

.meas tran vdout0_25ck90 FIND v(dout0_25) AT=50.025n

.meas tran vdout0_26ck90 FIND v(dout0_26) AT=50.025n

.meas tran vdout0_27ck90 FIND v(dout0_27) AT=50.025n

.meas tran vdout0_28ck90 FIND v(dout0_28) AT=50.025n

.meas tran vdout0_29ck90 FIND v(dout0_29) AT=50.025n

.meas tran vdout0_30ck90 FIND v(dout0_30) AT=50.025n

.meas tran vdout0_31ck90 FIND v(dout0_31) AT=50.025n

.meas tran vdout0_0ck100 FIND v(dout0_0) AT=55.025n

.meas tran vdout0_1ck100 FIND v(dout0_1) AT=55.025n

.meas tran vdout0_2ck100 FIND v(dout0_2) AT=55.025n

.meas tran vdout0_3ck100 FIND v(dout0_3) AT=55.025n

.meas tran vdout0_4ck100 FIND v(dout0_4) AT=55.025n

.meas tran vdout0_5ck100 FIND v(dout0_5) AT=55.025n

.meas tran vdout0_6ck100 FIND v(dout0_6) AT=55.025n

.meas tran vdout0_7ck100 FIND v(dout0_7) AT=55.025n

.meas tran vdout0_8ck100 FIND v(dout0_8) AT=55.025n

.meas tran vdout0_9ck100 FIND v(dout0_9) AT=55.025n

.meas tran vdout0_10ck100 FIND v(dout0_10) AT=55.025n

.meas tran vdout0_11ck100 FIND v(dout0_11) AT=55.025n

.meas tran vdout0_12ck100 FIND v(dout0_12) AT=55.025n

.meas tran vdout0_13ck100 FIND v(dout0_13) AT=55.025n

.meas tran vdout0_14ck100 FIND v(dout0_14) AT=55.025n

.meas tran vdout0_15ck100 FIND v(dout0_15) AT=55.025n

.meas tran vdout0_16ck100 FIND v(dout0_16) AT=55.025n

.meas tran vdout0_17ck100 FIND v(dout0_17) AT=55.025n

.meas tran vdout0_18ck100 FIND v(dout0_18) AT=55.025n

.meas tran vdout0_19ck100 FIND v(dout0_19) AT=55.025n

.meas tran vdout0_20ck100 FIND v(dout0_20) AT=55.025n

.meas tran vdout0_21ck100 FIND v(dout0_21) AT=55.025n

.meas tran vdout0_22ck100 FIND v(dout0_22) AT=55.025n

.meas tran vdout0_23ck100 FIND v(dout0_23) AT=55.025n

.meas tran vdout0_24ck100 FIND v(dout0_24) AT=55.025n

.meas tran vdout0_25ck100 FIND v(dout0_25) AT=55.025n

.meas tran vdout0_26ck100 FIND v(dout0_26) AT=55.025n

.meas tran vdout0_27ck100 FIND v(dout0_27) AT=55.025n

.meas tran vdout0_28ck100 FIND v(dout0_28) AT=55.025n

.meas tran vdout0_29ck100 FIND v(dout0_29) AT=55.025n

.meas tran vdout0_30ck100 FIND v(dout0_30) AT=55.025n

.meas tran vdout0_31ck100 FIND v(dout0_31) AT=55.025n

.meas tran vdout0_0ck110 FIND v(dout0_0) AT=60.025n

.meas tran vdout0_1ck110 FIND v(dout0_1) AT=60.025n

.meas tran vdout0_2ck110 FIND v(dout0_2) AT=60.025n

.meas tran vdout0_3ck110 FIND v(dout0_3) AT=60.025n

.meas tran vdout0_4ck110 FIND v(dout0_4) AT=60.025n

.meas tran vdout0_5ck110 FIND v(dout0_5) AT=60.025n

.meas tran vdout0_6ck110 FIND v(dout0_6) AT=60.025n

.meas tran vdout0_7ck110 FIND v(dout0_7) AT=60.025n

.meas tran vdout0_8ck110 FIND v(dout0_8) AT=60.025n

.meas tran vdout0_9ck110 FIND v(dout0_9) AT=60.025n

.meas tran vdout0_10ck110 FIND v(dout0_10) AT=60.025n

.meas tran vdout0_11ck110 FIND v(dout0_11) AT=60.025n

.meas tran vdout0_12ck110 FIND v(dout0_12) AT=60.025n

.meas tran vdout0_13ck110 FIND v(dout0_13) AT=60.025n

.meas tran vdout0_14ck110 FIND v(dout0_14) AT=60.025n

.meas tran vdout0_15ck110 FIND v(dout0_15) AT=60.025n

.meas tran vdout0_16ck110 FIND v(dout0_16) AT=60.025n

.meas tran vdout0_17ck110 FIND v(dout0_17) AT=60.025n

.meas tran vdout0_18ck110 FIND v(dout0_18) AT=60.025n

.meas tran vdout0_19ck110 FIND v(dout0_19) AT=60.025n

.meas tran vdout0_20ck110 FIND v(dout0_20) AT=60.025n

.meas tran vdout0_21ck110 FIND v(dout0_21) AT=60.025n

.meas tran vdout0_22ck110 FIND v(dout0_22) AT=60.025n

.meas tran vdout0_23ck110 FIND v(dout0_23) AT=60.025n

.meas tran vdout0_24ck110 FIND v(dout0_24) AT=60.025n

.meas tran vdout0_25ck110 FIND v(dout0_25) AT=60.025n

.meas tran vdout0_26ck110 FIND v(dout0_26) AT=60.025n

.meas tran vdout0_27ck110 FIND v(dout0_27) AT=60.025n

.meas tran vdout0_28ck110 FIND v(dout0_28) AT=60.025n

.meas tran vdout0_29ck110 FIND v(dout0_29) AT=60.025n

.meas tran vdout0_30ck110 FIND v(dout0_30) AT=60.025n

.meas tran vdout0_31ck110 FIND v(dout0_31) AT=60.025n

.meas tran vdout0_0ck180 FIND v(dout0_0) AT=95.025n

.meas tran vdout0_1ck180 FIND v(dout0_1) AT=95.025n

.meas tran vdout0_2ck180 FIND v(dout0_2) AT=95.025n

.meas tran vdout0_3ck180 FIND v(dout0_3) AT=95.025n

.meas tran vdout0_4ck180 FIND v(dout0_4) AT=95.025n

.meas tran vdout0_5ck180 FIND v(dout0_5) AT=95.025n

.meas tran vdout0_6ck180 FIND v(dout0_6) AT=95.025n

.meas tran vdout0_7ck180 FIND v(dout0_7) AT=95.025n

.meas tran vdout0_8ck180 FIND v(dout0_8) AT=95.025n

.meas tran vdout0_9ck180 FIND v(dout0_9) AT=95.025n

.meas tran vdout0_10ck180 FIND v(dout0_10) AT=95.025n

.meas tran vdout0_11ck180 FIND v(dout0_11) AT=95.025n

.meas tran vdout0_12ck180 FIND v(dout0_12) AT=95.025n

.meas tran vdout0_13ck180 FIND v(dout0_13) AT=95.025n

.meas tran vdout0_14ck180 FIND v(dout0_14) AT=95.025n

.meas tran vdout0_15ck180 FIND v(dout0_15) AT=95.025n

.meas tran vdout0_16ck180 FIND v(dout0_16) AT=95.025n

.meas tran vdout0_17ck180 FIND v(dout0_17) AT=95.025n

.meas tran vdout0_18ck180 FIND v(dout0_18) AT=95.025n

.meas tran vdout0_19ck180 FIND v(dout0_19) AT=95.025n

.meas tran vdout0_20ck180 FIND v(dout0_20) AT=95.025n

.meas tran vdout0_21ck180 FIND v(dout0_21) AT=95.025n

.meas tran vdout0_22ck180 FIND v(dout0_22) AT=95.025n

.meas tran vdout0_23ck180 FIND v(dout0_23) AT=95.025n

.meas tran vdout0_24ck180 FIND v(dout0_24) AT=95.025n

.meas tran vdout0_25ck180 FIND v(dout0_25) AT=95.025n

.meas tran vdout0_26ck180 FIND v(dout0_26) AT=95.025n

.meas tran vdout0_27ck180 FIND v(dout0_27) AT=95.025n

.meas tran vdout0_28ck180 FIND v(dout0_28) AT=95.025n

.meas tran vdout0_29ck180 FIND v(dout0_29) AT=95.025n

.meas tran vdout0_30ck180 FIND v(dout0_30) AT=95.025n

.meas tran vdout0_31ck180 FIND v(dout0_31) AT=95.025n

.meas tran vdout0_0ck200 FIND v(dout0_0) AT=105.025n

.meas tran vdout0_1ck200 FIND v(dout0_1) AT=105.025n

.meas tran vdout0_2ck200 FIND v(dout0_2) AT=105.025n

.meas tran vdout0_3ck200 FIND v(dout0_3) AT=105.025n

.meas tran vdout0_4ck200 FIND v(dout0_4) AT=105.025n

.meas tran vdout0_5ck200 FIND v(dout0_5) AT=105.025n

.meas tran vdout0_6ck200 FIND v(dout0_6) AT=105.025n

.meas tran vdout0_7ck200 FIND v(dout0_7) AT=105.025n

.meas tran vdout0_8ck200 FIND v(dout0_8) AT=105.025n

.meas tran vdout0_9ck200 FIND v(dout0_9) AT=105.025n

.meas tran vdout0_10ck200 FIND v(dout0_10) AT=105.025n

.meas tran vdout0_11ck200 FIND v(dout0_11) AT=105.025n

.meas tran vdout0_12ck200 FIND v(dout0_12) AT=105.025n

.meas tran vdout0_13ck200 FIND v(dout0_13) AT=105.025n

.meas tran vdout0_14ck200 FIND v(dout0_14) AT=105.025n

.meas tran vdout0_15ck200 FIND v(dout0_15) AT=105.025n

.meas tran vdout0_16ck200 FIND v(dout0_16) AT=105.025n

.meas tran vdout0_17ck200 FIND v(dout0_17) AT=105.025n

.meas tran vdout0_18ck200 FIND v(dout0_18) AT=105.025n

.meas tran vdout0_19ck200 FIND v(dout0_19) AT=105.025n

.meas tran vdout0_20ck200 FIND v(dout0_20) AT=105.025n

.meas tran vdout0_21ck200 FIND v(dout0_21) AT=105.025n

.meas tran vdout0_22ck200 FIND v(dout0_22) AT=105.025n

.meas tran vdout0_23ck200 FIND v(dout0_23) AT=105.025n

.meas tran vdout0_24ck200 FIND v(dout0_24) AT=105.025n

.meas tran vdout0_25ck200 FIND v(dout0_25) AT=105.025n

.meas tran vdout0_26ck200 FIND v(dout0_26) AT=105.025n

.meas tran vdout0_27ck200 FIND v(dout0_27) AT=105.025n

.meas tran vdout0_28ck200 FIND v(dout0_28) AT=105.025n

.meas tran vdout0_29ck200 FIND v(dout0_29) AT=105.025n

.meas tran vdout0_30ck200 FIND v(dout0_30) AT=105.025n

.meas tran vdout0_31ck200 FIND v(dout0_31) AT=105.025n

.meas tran vdout0_0ck240 FIND v(dout0_0) AT=125.025n

.meas tran vdout0_1ck240 FIND v(dout0_1) AT=125.025n

.meas tran vdout0_2ck240 FIND v(dout0_2) AT=125.025n

.meas tran vdout0_3ck240 FIND v(dout0_3) AT=125.025n

.meas tran vdout0_4ck240 FIND v(dout0_4) AT=125.025n

.meas tran vdout0_5ck240 FIND v(dout0_5) AT=125.025n

.meas tran vdout0_6ck240 FIND v(dout0_6) AT=125.025n

.meas tran vdout0_7ck240 FIND v(dout0_7) AT=125.025n

.meas tran vdout0_8ck240 FIND v(dout0_8) AT=125.025n

.meas tran vdout0_9ck240 FIND v(dout0_9) AT=125.025n

.meas tran vdout0_10ck240 FIND v(dout0_10) AT=125.025n

.meas tran vdout0_11ck240 FIND v(dout0_11) AT=125.025n

.meas tran vdout0_12ck240 FIND v(dout0_12) AT=125.025n

.meas tran vdout0_13ck240 FIND v(dout0_13) AT=125.025n

.meas tran vdout0_14ck240 FIND v(dout0_14) AT=125.025n

.meas tran vdout0_15ck240 FIND v(dout0_15) AT=125.025n

.meas tran vdout0_16ck240 FIND v(dout0_16) AT=125.025n

.meas tran vdout0_17ck240 FIND v(dout0_17) AT=125.025n

.meas tran vdout0_18ck240 FIND v(dout0_18) AT=125.025n

.meas tran vdout0_19ck240 FIND v(dout0_19) AT=125.025n

.meas tran vdout0_20ck240 FIND v(dout0_20) AT=125.025n

.meas tran vdout0_21ck240 FIND v(dout0_21) AT=125.025n

.meas tran vdout0_22ck240 FIND v(dout0_22) AT=125.025n

.meas tran vdout0_23ck240 FIND v(dout0_23) AT=125.025n

.meas tran vdout0_24ck240 FIND v(dout0_24) AT=125.025n

.meas tran vdout0_25ck240 FIND v(dout0_25) AT=125.025n

.meas tran vdout0_26ck240 FIND v(dout0_26) AT=125.025n

.meas tran vdout0_27ck240 FIND v(dout0_27) AT=125.025n

.meas tran vdout0_28ck240 FIND v(dout0_28) AT=125.025n

.meas tran vdout0_29ck240 FIND v(dout0_29) AT=125.025n

.meas tran vdout0_30ck240 FIND v(dout0_30) AT=125.025n

.meas tran vdout0_31ck240 FIND v(dout0_31) AT=125.025n

.meas tran vdout0_0ck250 FIND v(dout0_0) AT=130.025n

.meas tran vdout0_1ck250 FIND v(dout0_1) AT=130.025n

.meas tran vdout0_2ck250 FIND v(dout0_2) AT=130.025n

.meas tran vdout0_3ck250 FIND v(dout0_3) AT=130.025n

.meas tran vdout0_4ck250 FIND v(dout0_4) AT=130.025n

.meas tran vdout0_5ck250 FIND v(dout0_5) AT=130.025n

.meas tran vdout0_6ck250 FIND v(dout0_6) AT=130.025n

.meas tran vdout0_7ck250 FIND v(dout0_7) AT=130.025n

.meas tran vdout0_8ck250 FIND v(dout0_8) AT=130.025n

.meas tran vdout0_9ck250 FIND v(dout0_9) AT=130.025n

.meas tran vdout0_10ck250 FIND v(dout0_10) AT=130.025n

.meas tran vdout0_11ck250 FIND v(dout0_11) AT=130.025n

.meas tran vdout0_12ck250 FIND v(dout0_12) AT=130.025n

.meas tran vdout0_13ck250 FIND v(dout0_13) AT=130.025n

.meas tran vdout0_14ck250 FIND v(dout0_14) AT=130.025n

.meas tran vdout0_15ck250 FIND v(dout0_15) AT=130.025n

.meas tran vdout0_16ck250 FIND v(dout0_16) AT=130.025n

.meas tran vdout0_17ck250 FIND v(dout0_17) AT=130.025n

.meas tran vdout0_18ck250 FIND v(dout0_18) AT=130.025n

.meas tran vdout0_19ck250 FIND v(dout0_19) AT=130.025n

.meas tran vdout0_20ck250 FIND v(dout0_20) AT=130.025n

.meas tran vdout0_21ck250 FIND v(dout0_21) AT=130.025n

.meas tran vdout0_22ck250 FIND v(dout0_22) AT=130.025n

.meas tran vdout0_23ck250 FIND v(dout0_23) AT=130.025n

.meas tran vdout0_24ck250 FIND v(dout0_24) AT=130.025n

.meas tran vdout0_25ck250 FIND v(dout0_25) AT=130.025n

.meas tran vdout0_26ck250 FIND v(dout0_26) AT=130.025n

.meas tran vdout0_27ck250 FIND v(dout0_27) AT=130.025n

.meas tran vdout0_28ck250 FIND v(dout0_28) AT=130.025n

.meas tran vdout0_29ck250 FIND v(dout0_29) AT=130.025n

.meas tran vdout0_30ck250 FIND v(dout0_30) AT=130.025n

.meas tran vdout0_31ck250 FIND v(dout0_31) AT=130.025n

.meas tran vdout0_0ck290 FIND v(dout0_0) AT=150.025n

.meas tran vdout0_1ck290 FIND v(dout0_1) AT=150.025n

.meas tran vdout0_2ck290 FIND v(dout0_2) AT=150.025n

.meas tran vdout0_3ck290 FIND v(dout0_3) AT=150.025n

.meas tran vdout0_4ck290 FIND v(dout0_4) AT=150.025n

.meas tran vdout0_5ck290 FIND v(dout0_5) AT=150.025n

.meas tran vdout0_6ck290 FIND v(dout0_6) AT=150.025n

.meas tran vdout0_7ck290 FIND v(dout0_7) AT=150.025n

.meas tran vdout0_8ck290 FIND v(dout0_8) AT=150.025n

.meas tran vdout0_9ck290 FIND v(dout0_9) AT=150.025n

.meas tran vdout0_10ck290 FIND v(dout0_10) AT=150.025n

.meas tran vdout0_11ck290 FIND v(dout0_11) AT=150.025n

.meas tran vdout0_12ck290 FIND v(dout0_12) AT=150.025n

.meas tran vdout0_13ck290 FIND v(dout0_13) AT=150.025n

.meas tran vdout0_14ck290 FIND v(dout0_14) AT=150.025n

.meas tran vdout0_15ck290 FIND v(dout0_15) AT=150.025n

.meas tran vdout0_16ck290 FIND v(dout0_16) AT=150.025n

.meas tran vdout0_17ck290 FIND v(dout0_17) AT=150.025n

.meas tran vdout0_18ck290 FIND v(dout0_18) AT=150.025n

.meas tran vdout0_19ck290 FIND v(dout0_19) AT=150.025n

.meas tran vdout0_20ck290 FIND v(dout0_20) AT=150.025n

.meas tran vdout0_21ck290 FIND v(dout0_21) AT=150.025n

.meas tran vdout0_22ck290 FIND v(dout0_22) AT=150.025n

.meas tran vdout0_23ck290 FIND v(dout0_23) AT=150.025n

.meas tran vdout0_24ck290 FIND v(dout0_24) AT=150.025n

.meas tran vdout0_25ck290 FIND v(dout0_25) AT=150.025n

.meas tran vdout0_26ck290 FIND v(dout0_26) AT=150.025n

.meas tran vdout0_27ck290 FIND v(dout0_27) AT=150.025n

.meas tran vdout0_28ck290 FIND v(dout0_28) AT=150.025n

.meas tran vdout0_29ck290 FIND v(dout0_29) AT=150.025n

.meas tran vdout0_30ck290 FIND v(dout0_30) AT=150.025n

.meas tran vdout0_31ck290 FIND v(dout0_31) AT=150.025n

.meas tran vdout0_0ck320 FIND v(dout0_0) AT=165.025n

.meas tran vdout0_1ck320 FIND v(dout0_1) AT=165.025n

.meas tran vdout0_2ck320 FIND v(dout0_2) AT=165.025n

.meas tran vdout0_3ck320 FIND v(dout0_3) AT=165.025n

.meas tran vdout0_4ck320 FIND v(dout0_4) AT=165.025n

.meas tran vdout0_5ck320 FIND v(dout0_5) AT=165.025n

.meas tran vdout0_6ck320 FIND v(dout0_6) AT=165.025n

.meas tran vdout0_7ck320 FIND v(dout0_7) AT=165.025n

.meas tran vdout0_8ck320 FIND v(dout0_8) AT=165.025n

.meas tran vdout0_9ck320 FIND v(dout0_9) AT=165.025n

.meas tran vdout0_10ck320 FIND v(dout0_10) AT=165.025n

.meas tran vdout0_11ck320 FIND v(dout0_11) AT=165.025n

.meas tran vdout0_12ck320 FIND v(dout0_12) AT=165.025n

.meas tran vdout0_13ck320 FIND v(dout0_13) AT=165.025n

.meas tran vdout0_14ck320 FIND v(dout0_14) AT=165.025n

.meas tran vdout0_15ck320 FIND v(dout0_15) AT=165.025n

.meas tran vdout0_16ck320 FIND v(dout0_16) AT=165.025n

.meas tran vdout0_17ck320 FIND v(dout0_17) AT=165.025n

.meas tran vdout0_18ck320 FIND v(dout0_18) AT=165.025n

.meas tran vdout0_19ck320 FIND v(dout0_19) AT=165.025n

.meas tran vdout0_20ck320 FIND v(dout0_20) AT=165.025n

.meas tran vdout0_21ck320 FIND v(dout0_21) AT=165.025n

.meas tran vdout0_22ck320 FIND v(dout0_22) AT=165.025n

.meas tran vdout0_23ck320 FIND v(dout0_23) AT=165.025n

.meas tran vdout0_24ck320 FIND v(dout0_24) AT=165.025n

.meas tran vdout0_25ck320 FIND v(dout0_25) AT=165.025n

.meas tran vdout0_26ck320 FIND v(dout0_26) AT=165.025n

.meas tran vdout0_27ck320 FIND v(dout0_27) AT=165.025n

.meas tran vdout0_28ck320 FIND v(dout0_28) AT=165.025n

.meas tran vdout0_29ck320 FIND v(dout0_29) AT=165.025n

.meas tran vdout0_30ck320 FIND v(dout0_30) AT=165.025n

.meas tran vdout0_31ck320 FIND v(dout0_31) AT=165.025n

.meas tran vdout0_0ck330 FIND v(dout0_0) AT=170.025n

.meas tran vdout0_1ck330 FIND v(dout0_1) AT=170.025n

.meas tran vdout0_2ck330 FIND v(dout0_2) AT=170.025n

.meas tran vdout0_3ck330 FIND v(dout0_3) AT=170.025n

.meas tran vdout0_4ck330 FIND v(dout0_4) AT=170.025n

.meas tran vdout0_5ck330 FIND v(dout0_5) AT=170.025n

.meas tran vdout0_6ck330 FIND v(dout0_6) AT=170.025n

.meas tran vdout0_7ck330 FIND v(dout0_7) AT=170.025n

.meas tran vdout0_8ck330 FIND v(dout0_8) AT=170.025n

.meas tran vdout0_9ck330 FIND v(dout0_9) AT=170.025n

.meas tran vdout0_10ck330 FIND v(dout0_10) AT=170.025n

.meas tran vdout0_11ck330 FIND v(dout0_11) AT=170.025n

.meas tran vdout0_12ck330 FIND v(dout0_12) AT=170.025n

.meas tran vdout0_13ck330 FIND v(dout0_13) AT=170.025n

.meas tran vdout0_14ck330 FIND v(dout0_14) AT=170.025n

.meas tran vdout0_15ck330 FIND v(dout0_15) AT=170.025n

.meas tran vdout0_16ck330 FIND v(dout0_16) AT=170.025n

.meas tran vdout0_17ck330 FIND v(dout0_17) AT=170.025n

.meas tran vdout0_18ck330 FIND v(dout0_18) AT=170.025n

.meas tran vdout0_19ck330 FIND v(dout0_19) AT=170.025n

.meas tran vdout0_20ck330 FIND v(dout0_20) AT=170.025n

.meas tran vdout0_21ck330 FIND v(dout0_21) AT=170.025n

.meas tran vdout0_22ck330 FIND v(dout0_22) AT=170.025n

.meas tran vdout0_23ck330 FIND v(dout0_23) AT=170.025n

.meas tran vdout0_24ck330 FIND v(dout0_24) AT=170.025n

.meas tran vdout0_25ck330 FIND v(dout0_25) AT=170.025n

.meas tran vdout0_26ck330 FIND v(dout0_26) AT=170.025n

.meas tran vdout0_27ck330 FIND v(dout0_27) AT=170.025n

.meas tran vdout0_28ck330 FIND v(dout0_28) AT=170.025n

.meas tran vdout0_29ck330 FIND v(dout0_29) AT=170.025n

.meas tran vdout0_30ck330 FIND v(dout0_30) AT=170.025n

.meas tran vdout0_31ck330 FIND v(dout0_31) AT=170.025n

.meas tran vdout0_0ck340 FIND v(dout0_0) AT=175.025n

.meas tran vdout0_1ck340 FIND v(dout0_1) AT=175.025n

.meas tran vdout0_2ck340 FIND v(dout0_2) AT=175.025n

.meas tran vdout0_3ck340 FIND v(dout0_3) AT=175.025n

.meas tran vdout0_4ck340 FIND v(dout0_4) AT=175.025n

.meas tran vdout0_5ck340 FIND v(dout0_5) AT=175.025n

.meas tran vdout0_6ck340 FIND v(dout0_6) AT=175.025n

.meas tran vdout0_7ck340 FIND v(dout0_7) AT=175.025n

.meas tran vdout0_8ck340 FIND v(dout0_8) AT=175.025n

.meas tran vdout0_9ck340 FIND v(dout0_9) AT=175.025n

.meas tran vdout0_10ck340 FIND v(dout0_10) AT=175.025n

.meas tran vdout0_11ck340 FIND v(dout0_11) AT=175.025n

.meas tran vdout0_12ck340 FIND v(dout0_12) AT=175.025n

.meas tran vdout0_13ck340 FIND v(dout0_13) AT=175.025n

.meas tran vdout0_14ck340 FIND v(dout0_14) AT=175.025n

.meas tran vdout0_15ck340 FIND v(dout0_15) AT=175.025n

.meas tran vdout0_16ck340 FIND v(dout0_16) AT=175.025n

.meas tran vdout0_17ck340 FIND v(dout0_17) AT=175.025n

.meas tran vdout0_18ck340 FIND v(dout0_18) AT=175.025n

.meas tran vdout0_19ck340 FIND v(dout0_19) AT=175.025n

.meas tran vdout0_20ck340 FIND v(dout0_20) AT=175.025n

.meas tran vdout0_21ck340 FIND v(dout0_21) AT=175.025n

.meas tran vdout0_22ck340 FIND v(dout0_22) AT=175.025n

.meas tran vdout0_23ck340 FIND v(dout0_23) AT=175.025n

.meas tran vdout0_24ck340 FIND v(dout0_24) AT=175.025n

.meas tran vdout0_25ck340 FIND v(dout0_25) AT=175.025n

.meas tran vdout0_26ck340 FIND v(dout0_26) AT=175.025n

.meas tran vdout0_27ck340 FIND v(dout0_27) AT=175.025n

.meas tran vdout0_28ck340 FIND v(dout0_28) AT=175.025n

.meas tran vdout0_29ck340 FIND v(dout0_29) AT=175.025n

.meas tran vdout0_30ck340 FIND v(dout0_30) AT=175.025n

.meas tran vdout0_31ck340 FIND v(dout0_31) AT=175.025n

.meas tran vdout0_0ck350 FIND v(dout0_0) AT=180.025n

.meas tran vdout0_1ck350 FIND v(dout0_1) AT=180.025n

.meas tran vdout0_2ck350 FIND v(dout0_2) AT=180.025n

.meas tran vdout0_3ck350 FIND v(dout0_3) AT=180.025n

.meas tran vdout0_4ck350 FIND v(dout0_4) AT=180.025n

.meas tran vdout0_5ck350 FIND v(dout0_5) AT=180.025n

.meas tran vdout0_6ck350 FIND v(dout0_6) AT=180.025n

.meas tran vdout0_7ck350 FIND v(dout0_7) AT=180.025n

.meas tran vdout0_8ck350 FIND v(dout0_8) AT=180.025n

.meas tran vdout0_9ck350 FIND v(dout0_9) AT=180.025n

.meas tran vdout0_10ck350 FIND v(dout0_10) AT=180.025n

.meas tran vdout0_11ck350 FIND v(dout0_11) AT=180.025n

.meas tran vdout0_12ck350 FIND v(dout0_12) AT=180.025n

.meas tran vdout0_13ck350 FIND v(dout0_13) AT=180.025n

.meas tran vdout0_14ck350 FIND v(dout0_14) AT=180.025n

.meas tran vdout0_15ck350 FIND v(dout0_15) AT=180.025n

.meas tran vdout0_16ck350 FIND v(dout0_16) AT=180.025n

.meas tran vdout0_17ck350 FIND v(dout0_17) AT=180.025n

.meas tran vdout0_18ck350 FIND v(dout0_18) AT=180.025n

.meas tran vdout0_19ck350 FIND v(dout0_19) AT=180.025n

.meas tran vdout0_20ck350 FIND v(dout0_20) AT=180.025n

.meas tran vdout0_21ck350 FIND v(dout0_21) AT=180.025n

.meas tran vdout0_22ck350 FIND v(dout0_22) AT=180.025n

.meas tran vdout0_23ck350 FIND v(dout0_23) AT=180.025n

.meas tran vdout0_24ck350 FIND v(dout0_24) AT=180.025n

.meas tran vdout0_25ck350 FIND v(dout0_25) AT=180.025n

.meas tran vdout0_26ck350 FIND v(dout0_26) AT=180.025n

.meas tran vdout0_27ck350 FIND v(dout0_27) AT=180.025n

.meas tran vdout0_28ck350 FIND v(dout0_28) AT=180.025n

.meas tran vdout0_29ck350 FIND v(dout0_29) AT=180.025n

.meas tran vdout0_30ck350 FIND v(dout0_30) AT=180.025n

.meas tran vdout0_31ck350 FIND v(dout0_31) AT=180.025n

.meas tran vdout0_0ck360 FIND v(dout0_0) AT=185.025n

.meas tran vdout0_1ck360 FIND v(dout0_1) AT=185.025n

.meas tran vdout0_2ck360 FIND v(dout0_2) AT=185.025n

.meas tran vdout0_3ck360 FIND v(dout0_3) AT=185.025n

.meas tran vdout0_4ck360 FIND v(dout0_4) AT=185.025n

.meas tran vdout0_5ck360 FIND v(dout0_5) AT=185.025n

.meas tran vdout0_6ck360 FIND v(dout0_6) AT=185.025n

.meas tran vdout0_7ck360 FIND v(dout0_7) AT=185.025n

.meas tran vdout0_8ck360 FIND v(dout0_8) AT=185.025n

.meas tran vdout0_9ck360 FIND v(dout0_9) AT=185.025n

.meas tran vdout0_10ck360 FIND v(dout0_10) AT=185.025n

.meas tran vdout0_11ck360 FIND v(dout0_11) AT=185.025n

.meas tran vdout0_12ck360 FIND v(dout0_12) AT=185.025n

.meas tran vdout0_13ck360 FIND v(dout0_13) AT=185.025n

.meas tran vdout0_14ck360 FIND v(dout0_14) AT=185.025n

.meas tran vdout0_15ck360 FIND v(dout0_15) AT=185.025n

.meas tran vdout0_16ck360 FIND v(dout0_16) AT=185.025n

.meas tran vdout0_17ck360 FIND v(dout0_17) AT=185.025n

.meas tran vdout0_18ck360 FIND v(dout0_18) AT=185.025n

.meas tran vdout0_19ck360 FIND v(dout0_19) AT=185.025n

.meas tran vdout0_20ck360 FIND v(dout0_20) AT=185.025n

.meas tran vdout0_21ck360 FIND v(dout0_21) AT=185.025n

.meas tran vdout0_22ck360 FIND v(dout0_22) AT=185.025n

.meas tran vdout0_23ck360 FIND v(dout0_23) AT=185.025n

.meas tran vdout0_24ck360 FIND v(dout0_24) AT=185.025n

.meas tran vdout0_25ck360 FIND v(dout0_25) AT=185.025n

.meas tran vdout0_26ck360 FIND v(dout0_26) AT=185.025n

.meas tran vdout0_27ck360 FIND v(dout0_27) AT=185.025n

.meas tran vdout0_28ck360 FIND v(dout0_28) AT=185.025n

.meas tran vdout0_29ck360 FIND v(dout0_29) AT=185.025n

.meas tran vdout0_30ck360 FIND v(dout0_30) AT=185.025n

.meas tran vdout0_31ck360 FIND v(dout0_31) AT=185.025n

.meas tran vdout0_0ck370 FIND v(dout0_0) AT=190.025n

.meas tran vdout0_1ck370 FIND v(dout0_1) AT=190.025n

.meas tran vdout0_2ck370 FIND v(dout0_2) AT=190.025n

.meas tran vdout0_3ck370 FIND v(dout0_3) AT=190.025n

.meas tran vdout0_4ck370 FIND v(dout0_4) AT=190.025n

.meas tran vdout0_5ck370 FIND v(dout0_5) AT=190.025n

.meas tran vdout0_6ck370 FIND v(dout0_6) AT=190.025n

.meas tran vdout0_7ck370 FIND v(dout0_7) AT=190.025n

.meas tran vdout0_8ck370 FIND v(dout0_8) AT=190.025n

.meas tran vdout0_9ck370 FIND v(dout0_9) AT=190.025n

.meas tran vdout0_10ck370 FIND v(dout0_10) AT=190.025n

.meas tran vdout0_11ck370 FIND v(dout0_11) AT=190.025n

.meas tran vdout0_12ck370 FIND v(dout0_12) AT=190.025n

.meas tran vdout0_13ck370 FIND v(dout0_13) AT=190.025n

.meas tran vdout0_14ck370 FIND v(dout0_14) AT=190.025n

.meas tran vdout0_15ck370 FIND v(dout0_15) AT=190.025n

.meas tran vdout0_16ck370 FIND v(dout0_16) AT=190.025n

.meas tran vdout0_17ck370 FIND v(dout0_17) AT=190.025n

.meas tran vdout0_18ck370 FIND v(dout0_18) AT=190.025n

.meas tran vdout0_19ck370 FIND v(dout0_19) AT=190.025n

.meas tran vdout0_20ck370 FIND v(dout0_20) AT=190.025n

.meas tran vdout0_21ck370 FIND v(dout0_21) AT=190.025n

.meas tran vdout0_22ck370 FIND v(dout0_22) AT=190.025n

.meas tran vdout0_23ck370 FIND v(dout0_23) AT=190.025n

.meas tran vdout0_24ck370 FIND v(dout0_24) AT=190.025n

.meas tran vdout0_25ck370 FIND v(dout0_25) AT=190.025n

.meas tran vdout0_26ck370 FIND v(dout0_26) AT=190.025n

.meas tran vdout0_27ck370 FIND v(dout0_27) AT=190.025n

.meas tran vdout0_28ck370 FIND v(dout0_28) AT=190.025n

.meas tran vdout0_29ck370 FIND v(dout0_29) AT=190.025n

.meas tran vdout0_30ck370 FIND v(dout0_30) AT=190.025n

.meas tran vdout0_31ck370 FIND v(dout0_31) AT=190.025n

.meas tran vdout0_0ck380 FIND v(dout0_0) AT=195.025n

.meas tran vdout0_1ck380 FIND v(dout0_1) AT=195.025n

.meas tran vdout0_2ck380 FIND v(dout0_2) AT=195.025n

.meas tran vdout0_3ck380 FIND v(dout0_3) AT=195.025n

.meas tran vdout0_4ck380 FIND v(dout0_4) AT=195.025n

.meas tran vdout0_5ck380 FIND v(dout0_5) AT=195.025n

.meas tran vdout0_6ck380 FIND v(dout0_6) AT=195.025n

.meas tran vdout0_7ck380 FIND v(dout0_7) AT=195.025n

.meas tran vdout0_8ck380 FIND v(dout0_8) AT=195.025n

.meas tran vdout0_9ck380 FIND v(dout0_9) AT=195.025n

.meas tran vdout0_10ck380 FIND v(dout0_10) AT=195.025n

.meas tran vdout0_11ck380 FIND v(dout0_11) AT=195.025n

.meas tran vdout0_12ck380 FIND v(dout0_12) AT=195.025n

.meas tran vdout0_13ck380 FIND v(dout0_13) AT=195.025n

.meas tran vdout0_14ck380 FIND v(dout0_14) AT=195.025n

.meas tran vdout0_15ck380 FIND v(dout0_15) AT=195.025n

.meas tran vdout0_16ck380 FIND v(dout0_16) AT=195.025n

.meas tran vdout0_17ck380 FIND v(dout0_17) AT=195.025n

.meas tran vdout0_18ck380 FIND v(dout0_18) AT=195.025n

.meas tran vdout0_19ck380 FIND v(dout0_19) AT=195.025n

.meas tran vdout0_20ck380 FIND v(dout0_20) AT=195.025n

.meas tran vdout0_21ck380 FIND v(dout0_21) AT=195.025n

.meas tran vdout0_22ck380 FIND v(dout0_22) AT=195.025n

.meas tran vdout0_23ck380 FIND v(dout0_23) AT=195.025n

.meas tran vdout0_24ck380 FIND v(dout0_24) AT=195.025n

.meas tran vdout0_25ck380 FIND v(dout0_25) AT=195.025n

.meas tran vdout0_26ck380 FIND v(dout0_26) AT=195.025n

.meas tran vdout0_27ck380 FIND v(dout0_27) AT=195.025n

.meas tran vdout0_28ck380 FIND v(dout0_28) AT=195.025n

.meas tran vdout0_29ck380 FIND v(dout0_29) AT=195.025n

.meas tran vdout0_30ck380 FIND v(dout0_30) AT=195.025n

.meas tran vdout0_31ck380 FIND v(dout0_31) AT=195.025n

.meas tran vdout0_0ck390 FIND v(dout0_0) AT=200.025n

.meas tran vdout0_1ck390 FIND v(dout0_1) AT=200.025n

.meas tran vdout0_2ck390 FIND v(dout0_2) AT=200.025n

.meas tran vdout0_3ck390 FIND v(dout0_3) AT=200.025n

.meas tran vdout0_4ck390 FIND v(dout0_4) AT=200.025n

.meas tran vdout0_5ck390 FIND v(dout0_5) AT=200.025n

.meas tran vdout0_6ck390 FIND v(dout0_6) AT=200.025n

.meas tran vdout0_7ck390 FIND v(dout0_7) AT=200.025n

.meas tran vdout0_8ck390 FIND v(dout0_8) AT=200.025n

.meas tran vdout0_9ck390 FIND v(dout0_9) AT=200.025n

.meas tran vdout0_10ck390 FIND v(dout0_10) AT=200.025n

.meas tran vdout0_11ck390 FIND v(dout0_11) AT=200.025n

.meas tran vdout0_12ck390 FIND v(dout0_12) AT=200.025n

.meas tran vdout0_13ck390 FIND v(dout0_13) AT=200.025n

.meas tran vdout0_14ck390 FIND v(dout0_14) AT=200.025n

.meas tran vdout0_15ck390 FIND v(dout0_15) AT=200.025n

.meas tran vdout0_16ck390 FIND v(dout0_16) AT=200.025n

.meas tran vdout0_17ck390 FIND v(dout0_17) AT=200.025n

.meas tran vdout0_18ck390 FIND v(dout0_18) AT=200.025n

.meas tran vdout0_19ck390 FIND v(dout0_19) AT=200.025n

.meas tran vdout0_20ck390 FIND v(dout0_20) AT=200.025n

.meas tran vdout0_21ck390 FIND v(dout0_21) AT=200.025n

.meas tran vdout0_22ck390 FIND v(dout0_22) AT=200.025n

.meas tran vdout0_23ck390 FIND v(dout0_23) AT=200.025n

.meas tran vdout0_24ck390 FIND v(dout0_24) AT=200.025n

.meas tran vdout0_25ck390 FIND v(dout0_25) AT=200.025n

.meas tran vdout0_26ck390 FIND v(dout0_26) AT=200.025n

.meas tran vdout0_27ck390 FIND v(dout0_27) AT=200.025n

.meas tran vdout0_28ck390 FIND v(dout0_28) AT=200.025n

.meas tran vdout0_29ck390 FIND v(dout0_29) AT=200.025n

.meas tran vdout0_30ck390 FIND v(dout0_30) AT=200.025n

.meas tran vdout0_31ck390 FIND v(dout0_31) AT=200.025n

.meas tran vdout0_0ck400 FIND v(dout0_0) AT=205.025n

.meas tran vdout0_1ck400 FIND v(dout0_1) AT=205.025n

.meas tran vdout0_2ck400 FIND v(dout0_2) AT=205.025n

.meas tran vdout0_3ck400 FIND v(dout0_3) AT=205.025n

.meas tran vdout0_4ck400 FIND v(dout0_4) AT=205.025n

.meas tran vdout0_5ck400 FIND v(dout0_5) AT=205.025n

.meas tran vdout0_6ck400 FIND v(dout0_6) AT=205.025n

.meas tran vdout0_7ck400 FIND v(dout0_7) AT=205.025n

.meas tran vdout0_8ck400 FIND v(dout0_8) AT=205.025n

.meas tran vdout0_9ck400 FIND v(dout0_9) AT=205.025n

.meas tran vdout0_10ck400 FIND v(dout0_10) AT=205.025n

.meas tran vdout0_11ck400 FIND v(dout0_11) AT=205.025n

.meas tran vdout0_12ck400 FIND v(dout0_12) AT=205.025n

.meas tran vdout0_13ck400 FIND v(dout0_13) AT=205.025n

.meas tran vdout0_14ck400 FIND v(dout0_14) AT=205.025n

.meas tran vdout0_15ck400 FIND v(dout0_15) AT=205.025n

.meas tran vdout0_16ck400 FIND v(dout0_16) AT=205.025n

.meas tran vdout0_17ck400 FIND v(dout0_17) AT=205.025n

.meas tran vdout0_18ck400 FIND v(dout0_18) AT=205.025n

.meas tran vdout0_19ck400 FIND v(dout0_19) AT=205.025n

.meas tran vdout0_20ck400 FIND v(dout0_20) AT=205.025n

.meas tran vdout0_21ck400 FIND v(dout0_21) AT=205.025n

.meas tran vdout0_22ck400 FIND v(dout0_22) AT=205.025n

.meas tran vdout0_23ck400 FIND v(dout0_23) AT=205.025n

.meas tran vdout0_24ck400 FIND v(dout0_24) AT=205.025n

.meas tran vdout0_25ck400 FIND v(dout0_25) AT=205.025n

.meas tran vdout0_26ck400 FIND v(dout0_26) AT=205.025n

.meas tran vdout0_27ck400 FIND v(dout0_27) AT=205.025n

.meas tran vdout0_28ck400 FIND v(dout0_28) AT=205.025n

.meas tran vdout0_29ck400 FIND v(dout0_29) AT=205.025n

.meas tran vdout0_30ck400 FIND v(dout0_30) AT=205.025n

.meas tran vdout0_31ck400 FIND v(dout0_31) AT=205.025n

.meas tran vdout0_0ck410 FIND v(dout0_0) AT=210.025n

.meas tran vdout0_1ck410 FIND v(dout0_1) AT=210.025n

.meas tran vdout0_2ck410 FIND v(dout0_2) AT=210.025n

.meas tran vdout0_3ck410 FIND v(dout0_3) AT=210.025n

.meas tran vdout0_4ck410 FIND v(dout0_4) AT=210.025n

.meas tran vdout0_5ck410 FIND v(dout0_5) AT=210.025n

.meas tran vdout0_6ck410 FIND v(dout0_6) AT=210.025n

.meas tran vdout0_7ck410 FIND v(dout0_7) AT=210.025n

.meas tran vdout0_8ck410 FIND v(dout0_8) AT=210.025n

.meas tran vdout0_9ck410 FIND v(dout0_9) AT=210.025n

.meas tran vdout0_10ck410 FIND v(dout0_10) AT=210.025n

.meas tran vdout0_11ck410 FIND v(dout0_11) AT=210.025n

.meas tran vdout0_12ck410 FIND v(dout0_12) AT=210.025n

.meas tran vdout0_13ck410 FIND v(dout0_13) AT=210.025n

.meas tran vdout0_14ck410 FIND v(dout0_14) AT=210.025n

.meas tran vdout0_15ck410 FIND v(dout0_15) AT=210.025n

.meas tran vdout0_16ck410 FIND v(dout0_16) AT=210.025n

.meas tran vdout0_17ck410 FIND v(dout0_17) AT=210.025n

.meas tran vdout0_18ck410 FIND v(dout0_18) AT=210.025n

.meas tran vdout0_19ck410 FIND v(dout0_19) AT=210.025n

.meas tran vdout0_20ck410 FIND v(dout0_20) AT=210.025n

.meas tran vdout0_21ck410 FIND v(dout0_21) AT=210.025n

.meas tran vdout0_22ck410 FIND v(dout0_22) AT=210.025n

.meas tran vdout0_23ck410 FIND v(dout0_23) AT=210.025n

.meas tran vdout0_24ck410 FIND v(dout0_24) AT=210.025n

.meas tran vdout0_25ck410 FIND v(dout0_25) AT=210.025n

.meas tran vdout0_26ck410 FIND v(dout0_26) AT=210.025n

.meas tran vdout0_27ck410 FIND v(dout0_27) AT=210.025n

.meas tran vdout0_28ck410 FIND v(dout0_28) AT=210.025n

.meas tran vdout0_29ck410 FIND v(dout0_29) AT=210.025n

.meas tran vdout0_30ck410 FIND v(dout0_30) AT=210.025n

.meas tran vdout0_31ck410 FIND v(dout0_31) AT=210.025n

.meas tran vdout0_0ck430 FIND v(dout0_0) AT=220.025n

.meas tran vdout0_1ck430 FIND v(dout0_1) AT=220.025n

.meas tran vdout0_2ck430 FIND v(dout0_2) AT=220.025n

.meas tran vdout0_3ck430 FIND v(dout0_3) AT=220.025n

.meas tran vdout0_4ck430 FIND v(dout0_4) AT=220.025n

.meas tran vdout0_5ck430 FIND v(dout0_5) AT=220.025n

.meas tran vdout0_6ck430 FIND v(dout0_6) AT=220.025n

.meas tran vdout0_7ck430 FIND v(dout0_7) AT=220.025n

.meas tran vdout0_8ck430 FIND v(dout0_8) AT=220.025n

.meas tran vdout0_9ck430 FIND v(dout0_9) AT=220.025n

.meas tran vdout0_10ck430 FIND v(dout0_10) AT=220.025n

.meas tran vdout0_11ck430 FIND v(dout0_11) AT=220.025n

.meas tran vdout0_12ck430 FIND v(dout0_12) AT=220.025n

.meas tran vdout0_13ck430 FIND v(dout0_13) AT=220.025n

.meas tran vdout0_14ck430 FIND v(dout0_14) AT=220.025n

.meas tran vdout0_15ck430 FIND v(dout0_15) AT=220.025n

.meas tran vdout0_16ck430 FIND v(dout0_16) AT=220.025n

.meas tran vdout0_17ck430 FIND v(dout0_17) AT=220.025n

.meas tran vdout0_18ck430 FIND v(dout0_18) AT=220.025n

.meas tran vdout0_19ck430 FIND v(dout0_19) AT=220.025n

.meas tran vdout0_20ck430 FIND v(dout0_20) AT=220.025n

.meas tran vdout0_21ck430 FIND v(dout0_21) AT=220.025n

.meas tran vdout0_22ck430 FIND v(dout0_22) AT=220.025n

.meas tran vdout0_23ck430 FIND v(dout0_23) AT=220.025n

.meas tran vdout0_24ck430 FIND v(dout0_24) AT=220.025n

.meas tran vdout0_25ck430 FIND v(dout0_25) AT=220.025n

.meas tran vdout0_26ck430 FIND v(dout0_26) AT=220.025n

.meas tran vdout0_27ck430 FIND v(dout0_27) AT=220.025n

.meas tran vdout0_28ck430 FIND v(dout0_28) AT=220.025n

.meas tran vdout0_29ck430 FIND v(dout0_29) AT=220.025n

.meas tran vdout0_30ck430 FIND v(dout0_30) AT=220.025n

.meas tran vdout0_31ck430 FIND v(dout0_31) AT=220.025n

.meas tran vdout0_0ck440 FIND v(dout0_0) AT=225.025n

.meas tran vdout0_1ck440 FIND v(dout0_1) AT=225.025n

.meas tran vdout0_2ck440 FIND v(dout0_2) AT=225.025n

.meas tran vdout0_3ck440 FIND v(dout0_3) AT=225.025n

.meas tran vdout0_4ck440 FIND v(dout0_4) AT=225.025n

.meas tran vdout0_5ck440 FIND v(dout0_5) AT=225.025n

.meas tran vdout0_6ck440 FIND v(dout0_6) AT=225.025n

.meas tran vdout0_7ck440 FIND v(dout0_7) AT=225.025n

.meas tran vdout0_8ck440 FIND v(dout0_8) AT=225.025n

.meas tran vdout0_9ck440 FIND v(dout0_9) AT=225.025n

.meas tran vdout0_10ck440 FIND v(dout0_10) AT=225.025n

.meas tran vdout0_11ck440 FIND v(dout0_11) AT=225.025n

.meas tran vdout0_12ck440 FIND v(dout0_12) AT=225.025n

.meas tran vdout0_13ck440 FIND v(dout0_13) AT=225.025n

.meas tran vdout0_14ck440 FIND v(dout0_14) AT=225.025n

.meas tran vdout0_15ck440 FIND v(dout0_15) AT=225.025n

.meas tran vdout0_16ck440 FIND v(dout0_16) AT=225.025n

.meas tran vdout0_17ck440 FIND v(dout0_17) AT=225.025n

.meas tran vdout0_18ck440 FIND v(dout0_18) AT=225.025n

.meas tran vdout0_19ck440 FIND v(dout0_19) AT=225.025n

.meas tran vdout0_20ck440 FIND v(dout0_20) AT=225.025n

.meas tran vdout0_21ck440 FIND v(dout0_21) AT=225.025n

.meas tran vdout0_22ck440 FIND v(dout0_22) AT=225.025n

.meas tran vdout0_23ck440 FIND v(dout0_23) AT=225.025n

.meas tran vdout0_24ck440 FIND v(dout0_24) AT=225.025n

.meas tran vdout0_25ck440 FIND v(dout0_25) AT=225.025n

.meas tran vdout0_26ck440 FIND v(dout0_26) AT=225.025n

.meas tran vdout0_27ck440 FIND v(dout0_27) AT=225.025n

.meas tran vdout0_28ck440 FIND v(dout0_28) AT=225.025n

.meas tran vdout0_29ck440 FIND v(dout0_29) AT=225.025n

.meas tran vdout0_30ck440 FIND v(dout0_30) AT=225.025n

.meas tran vdout0_31ck440 FIND v(dout0_31) AT=225.025n

.meas tran vdout0_0ck460 FIND v(dout0_0) AT=235.025n

.meas tran vdout0_1ck460 FIND v(dout0_1) AT=235.025n

.meas tran vdout0_2ck460 FIND v(dout0_2) AT=235.025n

.meas tran vdout0_3ck460 FIND v(dout0_3) AT=235.025n

.meas tran vdout0_4ck460 FIND v(dout0_4) AT=235.025n

.meas tran vdout0_5ck460 FIND v(dout0_5) AT=235.025n

.meas tran vdout0_6ck460 FIND v(dout0_6) AT=235.025n

.meas tran vdout0_7ck460 FIND v(dout0_7) AT=235.025n

.meas tran vdout0_8ck460 FIND v(dout0_8) AT=235.025n

.meas tran vdout0_9ck460 FIND v(dout0_9) AT=235.025n

.meas tran vdout0_10ck460 FIND v(dout0_10) AT=235.025n

.meas tran vdout0_11ck460 FIND v(dout0_11) AT=235.025n

.meas tran vdout0_12ck460 FIND v(dout0_12) AT=235.025n

.meas tran vdout0_13ck460 FIND v(dout0_13) AT=235.025n

.meas tran vdout0_14ck460 FIND v(dout0_14) AT=235.025n

.meas tran vdout0_15ck460 FIND v(dout0_15) AT=235.025n

.meas tran vdout0_16ck460 FIND v(dout0_16) AT=235.025n

.meas tran vdout0_17ck460 FIND v(dout0_17) AT=235.025n

.meas tran vdout0_18ck460 FIND v(dout0_18) AT=235.025n

.meas tran vdout0_19ck460 FIND v(dout0_19) AT=235.025n

.meas tran vdout0_20ck460 FIND v(dout0_20) AT=235.025n

.meas tran vdout0_21ck460 FIND v(dout0_21) AT=235.025n

.meas tran vdout0_22ck460 FIND v(dout0_22) AT=235.025n

.meas tran vdout0_23ck460 FIND v(dout0_23) AT=235.025n

.meas tran vdout0_24ck460 FIND v(dout0_24) AT=235.025n

.meas tran vdout0_25ck460 FIND v(dout0_25) AT=235.025n

.meas tran vdout0_26ck460 FIND v(dout0_26) AT=235.025n

.meas tran vdout0_27ck460 FIND v(dout0_27) AT=235.025n

.meas tran vdout0_28ck460 FIND v(dout0_28) AT=235.025n

.meas tran vdout0_29ck460 FIND v(dout0_29) AT=235.025n

.meas tran vdout0_30ck460 FIND v(dout0_30) AT=235.025n

.meas tran vdout0_31ck460 FIND v(dout0_31) AT=235.025n

.meas tran vdout0_0ck480 FIND v(dout0_0) AT=245.025n

.meas tran vdout0_1ck480 FIND v(dout0_1) AT=245.025n

.meas tran vdout0_2ck480 FIND v(dout0_2) AT=245.025n

.meas tran vdout0_3ck480 FIND v(dout0_3) AT=245.025n

.meas tran vdout0_4ck480 FIND v(dout0_4) AT=245.025n

.meas tran vdout0_5ck480 FIND v(dout0_5) AT=245.025n

.meas tran vdout0_6ck480 FIND v(dout0_6) AT=245.025n

.meas tran vdout0_7ck480 FIND v(dout0_7) AT=245.025n

.meas tran vdout0_8ck480 FIND v(dout0_8) AT=245.025n

.meas tran vdout0_9ck480 FIND v(dout0_9) AT=245.025n

.meas tran vdout0_10ck480 FIND v(dout0_10) AT=245.025n

.meas tran vdout0_11ck480 FIND v(dout0_11) AT=245.025n

.meas tran vdout0_12ck480 FIND v(dout0_12) AT=245.025n

.meas tran vdout0_13ck480 FIND v(dout0_13) AT=245.025n

.meas tran vdout0_14ck480 FIND v(dout0_14) AT=245.025n

.meas tran vdout0_15ck480 FIND v(dout0_15) AT=245.025n

.meas tran vdout0_16ck480 FIND v(dout0_16) AT=245.025n

.meas tran vdout0_17ck480 FIND v(dout0_17) AT=245.025n

.meas tran vdout0_18ck480 FIND v(dout0_18) AT=245.025n

.meas tran vdout0_19ck480 FIND v(dout0_19) AT=245.025n

.meas tran vdout0_20ck480 FIND v(dout0_20) AT=245.025n

.meas tran vdout0_21ck480 FIND v(dout0_21) AT=245.025n

.meas tran vdout0_22ck480 FIND v(dout0_22) AT=245.025n

.meas tran vdout0_23ck480 FIND v(dout0_23) AT=245.025n

.meas tran vdout0_24ck480 FIND v(dout0_24) AT=245.025n

.meas tran vdout0_25ck480 FIND v(dout0_25) AT=245.025n

.meas tran vdout0_26ck480 FIND v(dout0_26) AT=245.025n

.meas tran vdout0_27ck480 FIND v(dout0_27) AT=245.025n

.meas tran vdout0_28ck480 FIND v(dout0_28) AT=245.025n

.meas tran vdout0_29ck480 FIND v(dout0_29) AT=245.025n

.meas tran vdout0_30ck480 FIND v(dout0_30) AT=245.025n

.meas tran vdout0_31ck480 FIND v(dout0_31) AT=245.025n

.meas tran vdout0_0ck500 FIND v(dout0_0) AT=255.025n

.meas tran vdout0_1ck500 FIND v(dout0_1) AT=255.025n

.meas tran vdout0_2ck500 FIND v(dout0_2) AT=255.025n

.meas tran vdout0_3ck500 FIND v(dout0_3) AT=255.025n

.meas tran vdout0_4ck500 FIND v(dout0_4) AT=255.025n

.meas tran vdout0_5ck500 FIND v(dout0_5) AT=255.025n

.meas tran vdout0_6ck500 FIND v(dout0_6) AT=255.025n

.meas tran vdout0_7ck500 FIND v(dout0_7) AT=255.025n

.meas tran vdout0_8ck500 FIND v(dout0_8) AT=255.025n

.meas tran vdout0_9ck500 FIND v(dout0_9) AT=255.025n

.meas tran vdout0_10ck500 FIND v(dout0_10) AT=255.025n

.meas tran vdout0_11ck500 FIND v(dout0_11) AT=255.025n

.meas tran vdout0_12ck500 FIND v(dout0_12) AT=255.025n

.meas tran vdout0_13ck500 FIND v(dout0_13) AT=255.025n

.meas tran vdout0_14ck500 FIND v(dout0_14) AT=255.025n

.meas tran vdout0_15ck500 FIND v(dout0_15) AT=255.025n

.meas tran vdout0_16ck500 FIND v(dout0_16) AT=255.025n

.meas tran vdout0_17ck500 FIND v(dout0_17) AT=255.025n

.meas tran vdout0_18ck500 FIND v(dout0_18) AT=255.025n

.meas tran vdout0_19ck500 FIND v(dout0_19) AT=255.025n

.meas tran vdout0_20ck500 FIND v(dout0_20) AT=255.025n

.meas tran vdout0_21ck500 FIND v(dout0_21) AT=255.025n

.meas tran vdout0_22ck500 FIND v(dout0_22) AT=255.025n

.meas tran vdout0_23ck500 FIND v(dout0_23) AT=255.025n

.meas tran vdout0_24ck500 FIND v(dout0_24) AT=255.025n

.meas tran vdout0_25ck500 FIND v(dout0_25) AT=255.025n

.meas tran vdout0_26ck500 FIND v(dout0_26) AT=255.025n

.meas tran vdout0_27ck500 FIND v(dout0_27) AT=255.025n

.meas tran vdout0_28ck500 FIND v(dout0_28) AT=255.025n

.meas tran vdout0_29ck500 FIND v(dout0_29) AT=255.025n

.meas tran vdout0_30ck500 FIND v(dout0_30) AT=255.025n

.meas tran vdout0_31ck500 FIND v(dout0_31) AT=255.025n

.meas tran vdout0_0ck510 FIND v(dout0_0) AT=260.025n

.meas tran vdout0_1ck510 FIND v(dout0_1) AT=260.025n

.meas tran vdout0_2ck510 FIND v(dout0_2) AT=260.025n

.meas tran vdout0_3ck510 FIND v(dout0_3) AT=260.025n

.meas tran vdout0_4ck510 FIND v(dout0_4) AT=260.025n

.meas tran vdout0_5ck510 FIND v(dout0_5) AT=260.025n

.meas tran vdout0_6ck510 FIND v(dout0_6) AT=260.025n

.meas tran vdout0_7ck510 FIND v(dout0_7) AT=260.025n

.meas tran vdout0_8ck510 FIND v(dout0_8) AT=260.025n

.meas tran vdout0_9ck510 FIND v(dout0_9) AT=260.025n

.meas tran vdout0_10ck510 FIND v(dout0_10) AT=260.025n

.meas tran vdout0_11ck510 FIND v(dout0_11) AT=260.025n

.meas tran vdout0_12ck510 FIND v(dout0_12) AT=260.025n

.meas tran vdout0_13ck510 FIND v(dout0_13) AT=260.025n

.meas tran vdout0_14ck510 FIND v(dout0_14) AT=260.025n

.meas tran vdout0_15ck510 FIND v(dout0_15) AT=260.025n

.meas tran vdout0_16ck510 FIND v(dout0_16) AT=260.025n

.meas tran vdout0_17ck510 FIND v(dout0_17) AT=260.025n

.meas tran vdout0_18ck510 FIND v(dout0_18) AT=260.025n

.meas tran vdout0_19ck510 FIND v(dout0_19) AT=260.025n

.meas tran vdout0_20ck510 FIND v(dout0_20) AT=260.025n

.meas tran vdout0_21ck510 FIND v(dout0_21) AT=260.025n

.meas tran vdout0_22ck510 FIND v(dout0_22) AT=260.025n

.meas tran vdout0_23ck510 FIND v(dout0_23) AT=260.025n

.meas tran vdout0_24ck510 FIND v(dout0_24) AT=260.025n

.meas tran vdout0_25ck510 FIND v(dout0_25) AT=260.025n

.meas tran vdout0_26ck510 FIND v(dout0_26) AT=260.025n

.meas tran vdout0_27ck510 FIND v(dout0_27) AT=260.025n

.meas tran vdout0_28ck510 FIND v(dout0_28) AT=260.025n

.meas tran vdout0_29ck510 FIND v(dout0_29) AT=260.025n

.meas tran vdout0_30ck510 FIND v(dout0_30) AT=260.025n

.meas tran vdout0_31ck510 FIND v(dout0_31) AT=260.025n

.meas tran vdout0_0ck550 FIND v(dout0_0) AT=280.025n

.meas tran vdout0_1ck550 FIND v(dout0_1) AT=280.025n

.meas tran vdout0_2ck550 FIND v(dout0_2) AT=280.025n

.meas tran vdout0_3ck550 FIND v(dout0_3) AT=280.025n

.meas tran vdout0_4ck550 FIND v(dout0_4) AT=280.025n

.meas tran vdout0_5ck550 FIND v(dout0_5) AT=280.025n

.meas tran vdout0_6ck550 FIND v(dout0_6) AT=280.025n

.meas tran vdout0_7ck550 FIND v(dout0_7) AT=280.025n

.meas tran vdout0_8ck550 FIND v(dout0_8) AT=280.025n

.meas tran vdout0_9ck550 FIND v(dout0_9) AT=280.025n

.meas tran vdout0_10ck550 FIND v(dout0_10) AT=280.025n

.meas tran vdout0_11ck550 FIND v(dout0_11) AT=280.025n

.meas tran vdout0_12ck550 FIND v(dout0_12) AT=280.025n

.meas tran vdout0_13ck550 FIND v(dout0_13) AT=280.025n

.meas tran vdout0_14ck550 FIND v(dout0_14) AT=280.025n

.meas tran vdout0_15ck550 FIND v(dout0_15) AT=280.025n

.meas tran vdout0_16ck550 FIND v(dout0_16) AT=280.025n

.meas tran vdout0_17ck550 FIND v(dout0_17) AT=280.025n

.meas tran vdout0_18ck550 FIND v(dout0_18) AT=280.025n

.meas tran vdout0_19ck550 FIND v(dout0_19) AT=280.025n

.meas tran vdout0_20ck550 FIND v(dout0_20) AT=280.025n

.meas tran vdout0_21ck550 FIND v(dout0_21) AT=280.025n

.meas tran vdout0_22ck550 FIND v(dout0_22) AT=280.025n

.meas tran vdout0_23ck550 FIND v(dout0_23) AT=280.025n

.meas tran vdout0_24ck550 FIND v(dout0_24) AT=280.025n

.meas tran vdout0_25ck550 FIND v(dout0_25) AT=280.025n

.meas tran vdout0_26ck550 FIND v(dout0_26) AT=280.025n

.meas tran vdout0_27ck550 FIND v(dout0_27) AT=280.025n

.meas tran vdout0_28ck550 FIND v(dout0_28) AT=280.025n

.meas tran vdout0_29ck550 FIND v(dout0_29) AT=280.025n

.meas tran vdout0_30ck550 FIND v(dout0_30) AT=280.025n

.meas tran vdout0_31ck550 FIND v(dout0_31) AT=280.025n

.meas tran vdout0_0ck560 FIND v(dout0_0) AT=285.025n

.meas tran vdout0_1ck560 FIND v(dout0_1) AT=285.025n

.meas tran vdout0_2ck560 FIND v(dout0_2) AT=285.025n

.meas tran vdout0_3ck560 FIND v(dout0_3) AT=285.025n

.meas tran vdout0_4ck560 FIND v(dout0_4) AT=285.025n

.meas tran vdout0_5ck560 FIND v(dout0_5) AT=285.025n

.meas tran vdout0_6ck560 FIND v(dout0_6) AT=285.025n

.meas tran vdout0_7ck560 FIND v(dout0_7) AT=285.025n

.meas tran vdout0_8ck560 FIND v(dout0_8) AT=285.025n

.meas tran vdout0_9ck560 FIND v(dout0_9) AT=285.025n

.meas tran vdout0_10ck560 FIND v(dout0_10) AT=285.025n

.meas tran vdout0_11ck560 FIND v(dout0_11) AT=285.025n

.meas tran vdout0_12ck560 FIND v(dout0_12) AT=285.025n

.meas tran vdout0_13ck560 FIND v(dout0_13) AT=285.025n

.meas tran vdout0_14ck560 FIND v(dout0_14) AT=285.025n

.meas tran vdout0_15ck560 FIND v(dout0_15) AT=285.025n

.meas tran vdout0_16ck560 FIND v(dout0_16) AT=285.025n

.meas tran vdout0_17ck560 FIND v(dout0_17) AT=285.025n

.meas tran vdout0_18ck560 FIND v(dout0_18) AT=285.025n

.meas tran vdout0_19ck560 FIND v(dout0_19) AT=285.025n

.meas tran vdout0_20ck560 FIND v(dout0_20) AT=285.025n

.meas tran vdout0_21ck560 FIND v(dout0_21) AT=285.025n

.meas tran vdout0_22ck560 FIND v(dout0_22) AT=285.025n

.meas tran vdout0_23ck560 FIND v(dout0_23) AT=285.025n

.meas tran vdout0_24ck560 FIND v(dout0_24) AT=285.025n

.meas tran vdout0_25ck560 FIND v(dout0_25) AT=285.025n

.meas tran vdout0_26ck560 FIND v(dout0_26) AT=285.025n

.meas tran vdout0_27ck560 FIND v(dout0_27) AT=285.025n

.meas tran vdout0_28ck560 FIND v(dout0_28) AT=285.025n

.meas tran vdout0_29ck560 FIND v(dout0_29) AT=285.025n

.meas tran vdout0_30ck560 FIND v(dout0_30) AT=285.025n

.meas tran vdout0_31ck560 FIND v(dout0_31) AT=285.025n

.meas tran vdout0_0ck570 FIND v(dout0_0) AT=290.025n

.meas tran vdout0_1ck570 FIND v(dout0_1) AT=290.025n

.meas tran vdout0_2ck570 FIND v(dout0_2) AT=290.025n

.meas tran vdout0_3ck570 FIND v(dout0_3) AT=290.025n

.meas tran vdout0_4ck570 FIND v(dout0_4) AT=290.025n

.meas tran vdout0_5ck570 FIND v(dout0_5) AT=290.025n

.meas tran vdout0_6ck570 FIND v(dout0_6) AT=290.025n

.meas tran vdout0_7ck570 FIND v(dout0_7) AT=290.025n

.meas tran vdout0_8ck570 FIND v(dout0_8) AT=290.025n

.meas tran vdout0_9ck570 FIND v(dout0_9) AT=290.025n

.meas tran vdout0_10ck570 FIND v(dout0_10) AT=290.025n

.meas tran vdout0_11ck570 FIND v(dout0_11) AT=290.025n

.meas tran vdout0_12ck570 FIND v(dout0_12) AT=290.025n

.meas tran vdout0_13ck570 FIND v(dout0_13) AT=290.025n

.meas tran vdout0_14ck570 FIND v(dout0_14) AT=290.025n

.meas tran vdout0_15ck570 FIND v(dout0_15) AT=290.025n

.meas tran vdout0_16ck570 FIND v(dout0_16) AT=290.025n

.meas tran vdout0_17ck570 FIND v(dout0_17) AT=290.025n

.meas tran vdout0_18ck570 FIND v(dout0_18) AT=290.025n

.meas tran vdout0_19ck570 FIND v(dout0_19) AT=290.025n

.meas tran vdout0_20ck570 FIND v(dout0_20) AT=290.025n

.meas tran vdout0_21ck570 FIND v(dout0_21) AT=290.025n

.meas tran vdout0_22ck570 FIND v(dout0_22) AT=290.025n

.meas tran vdout0_23ck570 FIND v(dout0_23) AT=290.025n

.meas tran vdout0_24ck570 FIND v(dout0_24) AT=290.025n

.meas tran vdout0_25ck570 FIND v(dout0_25) AT=290.025n

.meas tran vdout0_26ck570 FIND v(dout0_26) AT=290.025n

.meas tran vdout0_27ck570 FIND v(dout0_27) AT=290.025n

.meas tran vdout0_28ck570 FIND v(dout0_28) AT=290.025n

.meas tran vdout0_29ck570 FIND v(dout0_29) AT=290.025n

.meas tran vdout0_30ck570 FIND v(dout0_30) AT=290.025n

.meas tran vdout0_31ck570 FIND v(dout0_31) AT=290.025n

.meas tran vdout0_0ck580 FIND v(dout0_0) AT=295.025n

.meas tran vdout0_1ck580 FIND v(dout0_1) AT=295.025n

.meas tran vdout0_2ck580 FIND v(dout0_2) AT=295.025n

.meas tran vdout0_3ck580 FIND v(dout0_3) AT=295.025n

.meas tran vdout0_4ck580 FIND v(dout0_4) AT=295.025n

.meas tran vdout0_5ck580 FIND v(dout0_5) AT=295.025n

.meas tran vdout0_6ck580 FIND v(dout0_6) AT=295.025n

.meas tran vdout0_7ck580 FIND v(dout0_7) AT=295.025n

.meas tran vdout0_8ck580 FIND v(dout0_8) AT=295.025n

.meas tran vdout0_9ck580 FIND v(dout0_9) AT=295.025n

.meas tran vdout0_10ck580 FIND v(dout0_10) AT=295.025n

.meas tran vdout0_11ck580 FIND v(dout0_11) AT=295.025n

.meas tran vdout0_12ck580 FIND v(dout0_12) AT=295.025n

.meas tran vdout0_13ck580 FIND v(dout0_13) AT=295.025n

.meas tran vdout0_14ck580 FIND v(dout0_14) AT=295.025n

.meas tran vdout0_15ck580 FIND v(dout0_15) AT=295.025n

.meas tran vdout0_16ck580 FIND v(dout0_16) AT=295.025n

.meas tran vdout0_17ck580 FIND v(dout0_17) AT=295.025n

.meas tran vdout0_18ck580 FIND v(dout0_18) AT=295.025n

.meas tran vdout0_19ck580 FIND v(dout0_19) AT=295.025n

.meas tran vdout0_20ck580 FIND v(dout0_20) AT=295.025n

.meas tran vdout0_21ck580 FIND v(dout0_21) AT=295.025n

.meas tran vdout0_22ck580 FIND v(dout0_22) AT=295.025n

.meas tran vdout0_23ck580 FIND v(dout0_23) AT=295.025n

.meas tran vdout0_24ck580 FIND v(dout0_24) AT=295.025n

.meas tran vdout0_25ck580 FIND v(dout0_25) AT=295.025n

.meas tran vdout0_26ck580 FIND v(dout0_26) AT=295.025n

.meas tran vdout0_27ck580 FIND v(dout0_27) AT=295.025n

.meas tran vdout0_28ck580 FIND v(dout0_28) AT=295.025n

.meas tran vdout0_29ck580 FIND v(dout0_29) AT=295.025n

.meas tran vdout0_30ck580 FIND v(dout0_30) AT=295.025n

.meas tran vdout0_31ck580 FIND v(dout0_31) AT=295.025n

.meas tran vdout0_0ck600 FIND v(dout0_0) AT=305.025n

.meas tran vdout0_1ck600 FIND v(dout0_1) AT=305.025n

.meas tran vdout0_2ck600 FIND v(dout0_2) AT=305.025n

.meas tran vdout0_3ck600 FIND v(dout0_3) AT=305.025n

.meas tran vdout0_4ck600 FIND v(dout0_4) AT=305.025n

.meas tran vdout0_5ck600 FIND v(dout0_5) AT=305.025n

.meas tran vdout0_6ck600 FIND v(dout0_6) AT=305.025n

.meas tran vdout0_7ck600 FIND v(dout0_7) AT=305.025n

.meas tran vdout0_8ck600 FIND v(dout0_8) AT=305.025n

.meas tran vdout0_9ck600 FIND v(dout0_9) AT=305.025n

.meas tran vdout0_10ck600 FIND v(dout0_10) AT=305.025n

.meas tran vdout0_11ck600 FIND v(dout0_11) AT=305.025n

.meas tran vdout0_12ck600 FIND v(dout0_12) AT=305.025n

.meas tran vdout0_13ck600 FIND v(dout0_13) AT=305.025n

.meas tran vdout0_14ck600 FIND v(dout0_14) AT=305.025n

.meas tran vdout0_15ck600 FIND v(dout0_15) AT=305.025n

.meas tran vdout0_16ck600 FIND v(dout0_16) AT=305.025n

.meas tran vdout0_17ck600 FIND v(dout0_17) AT=305.025n

.meas tran vdout0_18ck600 FIND v(dout0_18) AT=305.025n

.meas tran vdout0_19ck600 FIND v(dout0_19) AT=305.025n

.meas tran vdout0_20ck600 FIND v(dout0_20) AT=305.025n

.meas tran vdout0_21ck600 FIND v(dout0_21) AT=305.025n

.meas tran vdout0_22ck600 FIND v(dout0_22) AT=305.025n

.meas tran vdout0_23ck600 FIND v(dout0_23) AT=305.025n

.meas tran vdout0_24ck600 FIND v(dout0_24) AT=305.025n

.meas tran vdout0_25ck600 FIND v(dout0_25) AT=305.025n

.meas tran vdout0_26ck600 FIND v(dout0_26) AT=305.025n

.meas tran vdout0_27ck600 FIND v(dout0_27) AT=305.025n

.meas tran vdout0_28ck600 FIND v(dout0_28) AT=305.025n

.meas tran vdout0_29ck600 FIND v(dout0_29) AT=305.025n

.meas tran vdout0_30ck600 FIND v(dout0_30) AT=305.025n

.meas tran vdout0_31ck600 FIND v(dout0_31) AT=305.025n

.meas tran vdout0_0ck610 FIND v(dout0_0) AT=310.025n

.meas tran vdout0_1ck610 FIND v(dout0_1) AT=310.025n

.meas tran vdout0_2ck610 FIND v(dout0_2) AT=310.025n

.meas tran vdout0_3ck610 FIND v(dout0_3) AT=310.025n

.meas tran vdout0_4ck610 FIND v(dout0_4) AT=310.025n

.meas tran vdout0_5ck610 FIND v(dout0_5) AT=310.025n

.meas tran vdout0_6ck610 FIND v(dout0_6) AT=310.025n

.meas tran vdout0_7ck610 FIND v(dout0_7) AT=310.025n

.meas tran vdout0_8ck610 FIND v(dout0_8) AT=310.025n

.meas tran vdout0_9ck610 FIND v(dout0_9) AT=310.025n

.meas tran vdout0_10ck610 FIND v(dout0_10) AT=310.025n

.meas tran vdout0_11ck610 FIND v(dout0_11) AT=310.025n

.meas tran vdout0_12ck610 FIND v(dout0_12) AT=310.025n

.meas tran vdout0_13ck610 FIND v(dout0_13) AT=310.025n

.meas tran vdout0_14ck610 FIND v(dout0_14) AT=310.025n

.meas tran vdout0_15ck610 FIND v(dout0_15) AT=310.025n

.meas tran vdout0_16ck610 FIND v(dout0_16) AT=310.025n

.meas tran vdout0_17ck610 FIND v(dout0_17) AT=310.025n

.meas tran vdout0_18ck610 FIND v(dout0_18) AT=310.025n

.meas tran vdout0_19ck610 FIND v(dout0_19) AT=310.025n

.meas tran vdout0_20ck610 FIND v(dout0_20) AT=310.025n

.meas tran vdout0_21ck610 FIND v(dout0_21) AT=310.025n

.meas tran vdout0_22ck610 FIND v(dout0_22) AT=310.025n

.meas tran vdout0_23ck610 FIND v(dout0_23) AT=310.025n

.meas tran vdout0_24ck610 FIND v(dout0_24) AT=310.025n

.meas tran vdout0_25ck610 FIND v(dout0_25) AT=310.025n

.meas tran vdout0_26ck610 FIND v(dout0_26) AT=310.025n

.meas tran vdout0_27ck610 FIND v(dout0_27) AT=310.025n

.meas tran vdout0_28ck610 FIND v(dout0_28) AT=310.025n

.meas tran vdout0_29ck610 FIND v(dout0_29) AT=310.025n

.meas tran vdout0_30ck610 FIND v(dout0_30) AT=310.025n

.meas tran vdout0_31ck610 FIND v(dout0_31) AT=310.025n

.meas tran vdout0_0ck630 FIND v(dout0_0) AT=320.025n

.meas tran vdout0_1ck630 FIND v(dout0_1) AT=320.025n

.meas tran vdout0_2ck630 FIND v(dout0_2) AT=320.025n

.meas tran vdout0_3ck630 FIND v(dout0_3) AT=320.025n

.meas tran vdout0_4ck630 FIND v(dout0_4) AT=320.025n

.meas tran vdout0_5ck630 FIND v(dout0_5) AT=320.025n

.meas tran vdout0_6ck630 FIND v(dout0_6) AT=320.025n

.meas tran vdout0_7ck630 FIND v(dout0_7) AT=320.025n

.meas tran vdout0_8ck630 FIND v(dout0_8) AT=320.025n

.meas tran vdout0_9ck630 FIND v(dout0_9) AT=320.025n

.meas tran vdout0_10ck630 FIND v(dout0_10) AT=320.025n

.meas tran vdout0_11ck630 FIND v(dout0_11) AT=320.025n

.meas tran vdout0_12ck630 FIND v(dout0_12) AT=320.025n

.meas tran vdout0_13ck630 FIND v(dout0_13) AT=320.025n

.meas tran vdout0_14ck630 FIND v(dout0_14) AT=320.025n

.meas tran vdout0_15ck630 FIND v(dout0_15) AT=320.025n

.meas tran vdout0_16ck630 FIND v(dout0_16) AT=320.025n

.meas tran vdout0_17ck630 FIND v(dout0_17) AT=320.025n

.meas tran vdout0_18ck630 FIND v(dout0_18) AT=320.025n

.meas tran vdout0_19ck630 FIND v(dout0_19) AT=320.025n

.meas tran vdout0_20ck630 FIND v(dout0_20) AT=320.025n

.meas tran vdout0_21ck630 FIND v(dout0_21) AT=320.025n

.meas tran vdout0_22ck630 FIND v(dout0_22) AT=320.025n

.meas tran vdout0_23ck630 FIND v(dout0_23) AT=320.025n

.meas tran vdout0_24ck630 FIND v(dout0_24) AT=320.025n

.meas tran vdout0_25ck630 FIND v(dout0_25) AT=320.025n

.meas tran vdout0_26ck630 FIND v(dout0_26) AT=320.025n

.meas tran vdout0_27ck630 FIND v(dout0_27) AT=320.025n

.meas tran vdout0_28ck630 FIND v(dout0_28) AT=320.025n

.meas tran vdout0_29ck630 FIND v(dout0_29) AT=320.025n

.meas tran vdout0_30ck630 FIND v(dout0_30) AT=320.025n

.meas tran vdout0_31ck630 FIND v(dout0_31) AT=320.025n

.meas tran vdout0_0ck640 FIND v(dout0_0) AT=325.025n

.meas tran vdout0_1ck640 FIND v(dout0_1) AT=325.025n

.meas tran vdout0_2ck640 FIND v(dout0_2) AT=325.025n

.meas tran vdout0_3ck640 FIND v(dout0_3) AT=325.025n

.meas tran vdout0_4ck640 FIND v(dout0_4) AT=325.025n

.meas tran vdout0_5ck640 FIND v(dout0_5) AT=325.025n

.meas tran vdout0_6ck640 FIND v(dout0_6) AT=325.025n

.meas tran vdout0_7ck640 FIND v(dout0_7) AT=325.025n

.meas tran vdout0_8ck640 FIND v(dout0_8) AT=325.025n

.meas tran vdout0_9ck640 FIND v(dout0_9) AT=325.025n

.meas tran vdout0_10ck640 FIND v(dout0_10) AT=325.025n

.meas tran vdout0_11ck640 FIND v(dout0_11) AT=325.025n

.meas tran vdout0_12ck640 FIND v(dout0_12) AT=325.025n

.meas tran vdout0_13ck640 FIND v(dout0_13) AT=325.025n

.meas tran vdout0_14ck640 FIND v(dout0_14) AT=325.025n

.meas tran vdout0_15ck640 FIND v(dout0_15) AT=325.025n

.meas tran vdout0_16ck640 FIND v(dout0_16) AT=325.025n

.meas tran vdout0_17ck640 FIND v(dout0_17) AT=325.025n

.meas tran vdout0_18ck640 FIND v(dout0_18) AT=325.025n

.meas tran vdout0_19ck640 FIND v(dout0_19) AT=325.025n

.meas tran vdout0_20ck640 FIND v(dout0_20) AT=325.025n

.meas tran vdout0_21ck640 FIND v(dout0_21) AT=325.025n

.meas tran vdout0_22ck640 FIND v(dout0_22) AT=325.025n

.meas tran vdout0_23ck640 FIND v(dout0_23) AT=325.025n

.meas tran vdout0_24ck640 FIND v(dout0_24) AT=325.025n

.meas tran vdout0_25ck640 FIND v(dout0_25) AT=325.025n

.meas tran vdout0_26ck640 FIND v(dout0_26) AT=325.025n

.meas tran vdout0_27ck640 FIND v(dout0_27) AT=325.025n

.meas tran vdout0_28ck640 FIND v(dout0_28) AT=325.025n

.meas tran vdout0_29ck640 FIND v(dout0_29) AT=325.025n

.meas tran vdout0_30ck640 FIND v(dout0_30) AT=325.025n

.meas tran vdout0_31ck640 FIND v(dout0_31) AT=325.025n

.meas tran vdout0_0ck660 FIND v(dout0_0) AT=335.025n

.meas tran vdout0_1ck660 FIND v(dout0_1) AT=335.025n

.meas tran vdout0_2ck660 FIND v(dout0_2) AT=335.025n

.meas tran vdout0_3ck660 FIND v(dout0_3) AT=335.025n

.meas tran vdout0_4ck660 FIND v(dout0_4) AT=335.025n

.meas tran vdout0_5ck660 FIND v(dout0_5) AT=335.025n

.meas tran vdout0_6ck660 FIND v(dout0_6) AT=335.025n

.meas tran vdout0_7ck660 FIND v(dout0_7) AT=335.025n

.meas tran vdout0_8ck660 FIND v(dout0_8) AT=335.025n

.meas tran vdout0_9ck660 FIND v(dout0_9) AT=335.025n

.meas tran vdout0_10ck660 FIND v(dout0_10) AT=335.025n

.meas tran vdout0_11ck660 FIND v(dout0_11) AT=335.025n

.meas tran vdout0_12ck660 FIND v(dout0_12) AT=335.025n

.meas tran vdout0_13ck660 FIND v(dout0_13) AT=335.025n

.meas tran vdout0_14ck660 FIND v(dout0_14) AT=335.025n

.meas tran vdout0_15ck660 FIND v(dout0_15) AT=335.025n

.meas tran vdout0_16ck660 FIND v(dout0_16) AT=335.025n

.meas tran vdout0_17ck660 FIND v(dout0_17) AT=335.025n

.meas tran vdout0_18ck660 FIND v(dout0_18) AT=335.025n

.meas tran vdout0_19ck660 FIND v(dout0_19) AT=335.025n

.meas tran vdout0_20ck660 FIND v(dout0_20) AT=335.025n

.meas tran vdout0_21ck660 FIND v(dout0_21) AT=335.025n

.meas tran vdout0_22ck660 FIND v(dout0_22) AT=335.025n

.meas tran vdout0_23ck660 FIND v(dout0_23) AT=335.025n

.meas tran vdout0_24ck660 FIND v(dout0_24) AT=335.025n

.meas tran vdout0_25ck660 FIND v(dout0_25) AT=335.025n

.meas tran vdout0_26ck660 FIND v(dout0_26) AT=335.025n

.meas tran vdout0_27ck660 FIND v(dout0_27) AT=335.025n

.meas tran vdout0_28ck660 FIND v(dout0_28) AT=335.025n

.meas tran vdout0_29ck660 FIND v(dout0_29) AT=335.025n

.meas tran vdout0_30ck660 FIND v(dout0_30) AT=335.025n

.meas tran vdout0_31ck660 FIND v(dout0_31) AT=335.025n

.meas tran vdout0_0ck680 FIND v(dout0_0) AT=345.025n

.meas tran vdout0_1ck680 FIND v(dout0_1) AT=345.025n

.meas tran vdout0_2ck680 FIND v(dout0_2) AT=345.025n

.meas tran vdout0_3ck680 FIND v(dout0_3) AT=345.025n

.meas tran vdout0_4ck680 FIND v(dout0_4) AT=345.025n

.meas tran vdout0_5ck680 FIND v(dout0_5) AT=345.025n

.meas tran vdout0_6ck680 FIND v(dout0_6) AT=345.025n

.meas tran vdout0_7ck680 FIND v(dout0_7) AT=345.025n

.meas tran vdout0_8ck680 FIND v(dout0_8) AT=345.025n

.meas tran vdout0_9ck680 FIND v(dout0_9) AT=345.025n

.meas tran vdout0_10ck680 FIND v(dout0_10) AT=345.025n

.meas tran vdout0_11ck680 FIND v(dout0_11) AT=345.025n

.meas tran vdout0_12ck680 FIND v(dout0_12) AT=345.025n

.meas tran vdout0_13ck680 FIND v(dout0_13) AT=345.025n

.meas tran vdout0_14ck680 FIND v(dout0_14) AT=345.025n

.meas tran vdout0_15ck680 FIND v(dout0_15) AT=345.025n

.meas tran vdout0_16ck680 FIND v(dout0_16) AT=345.025n

.meas tran vdout0_17ck680 FIND v(dout0_17) AT=345.025n

.meas tran vdout0_18ck680 FIND v(dout0_18) AT=345.025n

.meas tran vdout0_19ck680 FIND v(dout0_19) AT=345.025n

.meas tran vdout0_20ck680 FIND v(dout0_20) AT=345.025n

.meas tran vdout0_21ck680 FIND v(dout0_21) AT=345.025n

.meas tran vdout0_22ck680 FIND v(dout0_22) AT=345.025n

.meas tran vdout0_23ck680 FIND v(dout0_23) AT=345.025n

.meas tran vdout0_24ck680 FIND v(dout0_24) AT=345.025n

.meas tran vdout0_25ck680 FIND v(dout0_25) AT=345.025n

.meas tran vdout0_26ck680 FIND v(dout0_26) AT=345.025n

.meas tran vdout0_27ck680 FIND v(dout0_27) AT=345.025n

.meas tran vdout0_28ck680 FIND v(dout0_28) AT=345.025n

.meas tran vdout0_29ck680 FIND v(dout0_29) AT=345.025n

.meas tran vdout0_30ck680 FIND v(dout0_30) AT=345.025n

.meas tran vdout0_31ck680 FIND v(dout0_31) AT=345.025n

.meas tran vdout0_0ck690 FIND v(dout0_0) AT=350.025n

.meas tran vdout0_1ck690 FIND v(dout0_1) AT=350.025n

.meas tran vdout0_2ck690 FIND v(dout0_2) AT=350.025n

.meas tran vdout0_3ck690 FIND v(dout0_3) AT=350.025n

.meas tran vdout0_4ck690 FIND v(dout0_4) AT=350.025n

.meas tran vdout0_5ck690 FIND v(dout0_5) AT=350.025n

.meas tran vdout0_6ck690 FIND v(dout0_6) AT=350.025n

.meas tran vdout0_7ck690 FIND v(dout0_7) AT=350.025n

.meas tran vdout0_8ck690 FIND v(dout0_8) AT=350.025n

.meas tran vdout0_9ck690 FIND v(dout0_9) AT=350.025n

.meas tran vdout0_10ck690 FIND v(dout0_10) AT=350.025n

.meas tran vdout0_11ck690 FIND v(dout0_11) AT=350.025n

.meas tran vdout0_12ck690 FIND v(dout0_12) AT=350.025n

.meas tran vdout0_13ck690 FIND v(dout0_13) AT=350.025n

.meas tran vdout0_14ck690 FIND v(dout0_14) AT=350.025n

.meas tran vdout0_15ck690 FIND v(dout0_15) AT=350.025n

.meas tran vdout0_16ck690 FIND v(dout0_16) AT=350.025n

.meas tran vdout0_17ck690 FIND v(dout0_17) AT=350.025n

.meas tran vdout0_18ck690 FIND v(dout0_18) AT=350.025n

.meas tran vdout0_19ck690 FIND v(dout0_19) AT=350.025n

.meas tran vdout0_20ck690 FIND v(dout0_20) AT=350.025n

.meas tran vdout0_21ck690 FIND v(dout0_21) AT=350.025n

.meas tran vdout0_22ck690 FIND v(dout0_22) AT=350.025n

.meas tran vdout0_23ck690 FIND v(dout0_23) AT=350.025n

.meas tran vdout0_24ck690 FIND v(dout0_24) AT=350.025n

.meas tran vdout0_25ck690 FIND v(dout0_25) AT=350.025n

.meas tran vdout0_26ck690 FIND v(dout0_26) AT=350.025n

.meas tran vdout0_27ck690 FIND v(dout0_27) AT=350.025n

.meas tran vdout0_28ck690 FIND v(dout0_28) AT=350.025n

.meas tran vdout0_29ck690 FIND v(dout0_29) AT=350.025n

.meas tran vdout0_30ck690 FIND v(dout0_30) AT=350.025n

.meas tran vdout0_31ck690 FIND v(dout0_31) AT=350.025n

.meas tran vdout0_0ck720 FIND v(dout0_0) AT=365.025n

.meas tran vdout0_1ck720 FIND v(dout0_1) AT=365.025n

.meas tran vdout0_2ck720 FIND v(dout0_2) AT=365.025n

.meas tran vdout0_3ck720 FIND v(dout0_3) AT=365.025n

.meas tran vdout0_4ck720 FIND v(dout0_4) AT=365.025n

.meas tran vdout0_5ck720 FIND v(dout0_5) AT=365.025n

.meas tran vdout0_6ck720 FIND v(dout0_6) AT=365.025n

.meas tran vdout0_7ck720 FIND v(dout0_7) AT=365.025n

.meas tran vdout0_8ck720 FIND v(dout0_8) AT=365.025n

.meas tran vdout0_9ck720 FIND v(dout0_9) AT=365.025n

.meas tran vdout0_10ck720 FIND v(dout0_10) AT=365.025n

.meas tran vdout0_11ck720 FIND v(dout0_11) AT=365.025n

.meas tran vdout0_12ck720 FIND v(dout0_12) AT=365.025n

.meas tran vdout0_13ck720 FIND v(dout0_13) AT=365.025n

.meas tran vdout0_14ck720 FIND v(dout0_14) AT=365.025n

.meas tran vdout0_15ck720 FIND v(dout0_15) AT=365.025n

.meas tran vdout0_16ck720 FIND v(dout0_16) AT=365.025n

.meas tran vdout0_17ck720 FIND v(dout0_17) AT=365.025n

.meas tran vdout0_18ck720 FIND v(dout0_18) AT=365.025n

.meas tran vdout0_19ck720 FIND v(dout0_19) AT=365.025n

.meas tran vdout0_20ck720 FIND v(dout0_20) AT=365.025n

.meas tran vdout0_21ck720 FIND v(dout0_21) AT=365.025n

.meas tran vdout0_22ck720 FIND v(dout0_22) AT=365.025n

.meas tran vdout0_23ck720 FIND v(dout0_23) AT=365.025n

.meas tran vdout0_24ck720 FIND v(dout0_24) AT=365.025n

.meas tran vdout0_25ck720 FIND v(dout0_25) AT=365.025n

.meas tran vdout0_26ck720 FIND v(dout0_26) AT=365.025n

.meas tran vdout0_27ck720 FIND v(dout0_27) AT=365.025n

.meas tran vdout0_28ck720 FIND v(dout0_28) AT=365.025n

.meas tran vdout0_29ck720 FIND v(dout0_29) AT=365.025n

.meas tran vdout0_30ck720 FIND v(dout0_30) AT=365.025n

.meas tran vdout0_31ck720 FIND v(dout0_31) AT=365.025n

.meas tran vdout0_0ck740 FIND v(dout0_0) AT=375.025n

.meas tran vdout0_1ck740 FIND v(dout0_1) AT=375.025n

.meas tran vdout0_2ck740 FIND v(dout0_2) AT=375.025n

.meas tran vdout0_3ck740 FIND v(dout0_3) AT=375.025n

.meas tran vdout0_4ck740 FIND v(dout0_4) AT=375.025n

.meas tran vdout0_5ck740 FIND v(dout0_5) AT=375.025n

.meas tran vdout0_6ck740 FIND v(dout0_6) AT=375.025n

.meas tran vdout0_7ck740 FIND v(dout0_7) AT=375.025n

.meas tran vdout0_8ck740 FIND v(dout0_8) AT=375.025n

.meas tran vdout0_9ck740 FIND v(dout0_9) AT=375.025n

.meas tran vdout0_10ck740 FIND v(dout0_10) AT=375.025n

.meas tran vdout0_11ck740 FIND v(dout0_11) AT=375.025n

.meas tran vdout0_12ck740 FIND v(dout0_12) AT=375.025n

.meas tran vdout0_13ck740 FIND v(dout0_13) AT=375.025n

.meas tran vdout0_14ck740 FIND v(dout0_14) AT=375.025n

.meas tran vdout0_15ck740 FIND v(dout0_15) AT=375.025n

.meas tran vdout0_16ck740 FIND v(dout0_16) AT=375.025n

.meas tran vdout0_17ck740 FIND v(dout0_17) AT=375.025n

.meas tran vdout0_18ck740 FIND v(dout0_18) AT=375.025n

.meas tran vdout0_19ck740 FIND v(dout0_19) AT=375.025n

.meas tran vdout0_20ck740 FIND v(dout0_20) AT=375.025n

.meas tran vdout0_21ck740 FIND v(dout0_21) AT=375.025n

.meas tran vdout0_22ck740 FIND v(dout0_22) AT=375.025n

.meas tran vdout0_23ck740 FIND v(dout0_23) AT=375.025n

.meas tran vdout0_24ck740 FIND v(dout0_24) AT=375.025n

.meas tran vdout0_25ck740 FIND v(dout0_25) AT=375.025n

.meas tran vdout0_26ck740 FIND v(dout0_26) AT=375.025n

.meas tran vdout0_27ck740 FIND v(dout0_27) AT=375.025n

.meas tran vdout0_28ck740 FIND v(dout0_28) AT=375.025n

.meas tran vdout0_29ck740 FIND v(dout0_29) AT=375.025n

.meas tran vdout0_30ck740 FIND v(dout0_30) AT=375.025n

.meas tran vdout0_31ck740 FIND v(dout0_31) AT=375.025n

.meas tran vdout0_0ck750 FIND v(dout0_0) AT=380.025n

.meas tran vdout0_1ck750 FIND v(dout0_1) AT=380.025n

.meas tran vdout0_2ck750 FIND v(dout0_2) AT=380.025n

.meas tran vdout0_3ck750 FIND v(dout0_3) AT=380.025n

.meas tran vdout0_4ck750 FIND v(dout0_4) AT=380.025n

.meas tran vdout0_5ck750 FIND v(dout0_5) AT=380.025n

.meas tran vdout0_6ck750 FIND v(dout0_6) AT=380.025n

.meas tran vdout0_7ck750 FIND v(dout0_7) AT=380.025n

.meas tran vdout0_8ck750 FIND v(dout0_8) AT=380.025n

.meas tran vdout0_9ck750 FIND v(dout0_9) AT=380.025n

.meas tran vdout0_10ck750 FIND v(dout0_10) AT=380.025n

.meas tran vdout0_11ck750 FIND v(dout0_11) AT=380.025n

.meas tran vdout0_12ck750 FIND v(dout0_12) AT=380.025n

.meas tran vdout0_13ck750 FIND v(dout0_13) AT=380.025n

.meas tran vdout0_14ck750 FIND v(dout0_14) AT=380.025n

.meas tran vdout0_15ck750 FIND v(dout0_15) AT=380.025n

.meas tran vdout0_16ck750 FIND v(dout0_16) AT=380.025n

.meas tran vdout0_17ck750 FIND v(dout0_17) AT=380.025n

.meas tran vdout0_18ck750 FIND v(dout0_18) AT=380.025n

.meas tran vdout0_19ck750 FIND v(dout0_19) AT=380.025n

.meas tran vdout0_20ck750 FIND v(dout0_20) AT=380.025n

.meas tran vdout0_21ck750 FIND v(dout0_21) AT=380.025n

.meas tran vdout0_22ck750 FIND v(dout0_22) AT=380.025n

.meas tran vdout0_23ck750 FIND v(dout0_23) AT=380.025n

.meas tran vdout0_24ck750 FIND v(dout0_24) AT=380.025n

.meas tran vdout0_25ck750 FIND v(dout0_25) AT=380.025n

.meas tran vdout0_26ck750 FIND v(dout0_26) AT=380.025n

.meas tran vdout0_27ck750 FIND v(dout0_27) AT=380.025n

.meas tran vdout0_28ck750 FIND v(dout0_28) AT=380.025n

.meas tran vdout0_29ck750 FIND v(dout0_29) AT=380.025n

.meas tran vdout0_30ck750 FIND v(dout0_30) AT=380.025n

.meas tran vdout0_31ck750 FIND v(dout0_31) AT=380.025n

.meas tran vdout0_0ck770 FIND v(dout0_0) AT=390.025n

.meas tran vdout0_1ck770 FIND v(dout0_1) AT=390.025n

.meas tran vdout0_2ck770 FIND v(dout0_2) AT=390.025n

.meas tran vdout0_3ck770 FIND v(dout0_3) AT=390.025n

.meas tran vdout0_4ck770 FIND v(dout0_4) AT=390.025n

.meas tran vdout0_5ck770 FIND v(dout0_5) AT=390.025n

.meas tran vdout0_6ck770 FIND v(dout0_6) AT=390.025n

.meas tran vdout0_7ck770 FIND v(dout0_7) AT=390.025n

.meas tran vdout0_8ck770 FIND v(dout0_8) AT=390.025n

.meas tran vdout0_9ck770 FIND v(dout0_9) AT=390.025n

.meas tran vdout0_10ck770 FIND v(dout0_10) AT=390.025n

.meas tran vdout0_11ck770 FIND v(dout0_11) AT=390.025n

.meas tran vdout0_12ck770 FIND v(dout0_12) AT=390.025n

.meas tran vdout0_13ck770 FIND v(dout0_13) AT=390.025n

.meas tran vdout0_14ck770 FIND v(dout0_14) AT=390.025n

.meas tran vdout0_15ck770 FIND v(dout0_15) AT=390.025n

.meas tran vdout0_16ck770 FIND v(dout0_16) AT=390.025n

.meas tran vdout0_17ck770 FIND v(dout0_17) AT=390.025n

.meas tran vdout0_18ck770 FIND v(dout0_18) AT=390.025n

.meas tran vdout0_19ck770 FIND v(dout0_19) AT=390.025n

.meas tran vdout0_20ck770 FIND v(dout0_20) AT=390.025n

.meas tran vdout0_21ck770 FIND v(dout0_21) AT=390.025n

.meas tran vdout0_22ck770 FIND v(dout0_22) AT=390.025n

.meas tran vdout0_23ck770 FIND v(dout0_23) AT=390.025n

.meas tran vdout0_24ck770 FIND v(dout0_24) AT=390.025n

.meas tran vdout0_25ck770 FIND v(dout0_25) AT=390.025n

.meas tran vdout0_26ck770 FIND v(dout0_26) AT=390.025n

.meas tran vdout0_27ck770 FIND v(dout0_27) AT=390.025n

.meas tran vdout0_28ck770 FIND v(dout0_28) AT=390.025n

.meas tran vdout0_29ck770 FIND v(dout0_29) AT=390.025n

.meas tran vdout0_30ck770 FIND v(dout0_30) AT=390.025n

.meas tran vdout0_31ck770 FIND v(dout0_31) AT=390.025n

.meas tran vdout0_0ck780 FIND v(dout0_0) AT=395.025n

.meas tran vdout0_1ck780 FIND v(dout0_1) AT=395.025n

.meas tran vdout0_2ck780 FIND v(dout0_2) AT=395.025n

.meas tran vdout0_3ck780 FIND v(dout0_3) AT=395.025n

.meas tran vdout0_4ck780 FIND v(dout0_4) AT=395.025n

.meas tran vdout0_5ck780 FIND v(dout0_5) AT=395.025n

.meas tran vdout0_6ck780 FIND v(dout0_6) AT=395.025n

.meas tran vdout0_7ck780 FIND v(dout0_7) AT=395.025n

.meas tran vdout0_8ck780 FIND v(dout0_8) AT=395.025n

.meas tran vdout0_9ck780 FIND v(dout0_9) AT=395.025n

.meas tran vdout0_10ck780 FIND v(dout0_10) AT=395.025n

.meas tran vdout0_11ck780 FIND v(dout0_11) AT=395.025n

.meas tran vdout0_12ck780 FIND v(dout0_12) AT=395.025n

.meas tran vdout0_13ck780 FIND v(dout0_13) AT=395.025n

.meas tran vdout0_14ck780 FIND v(dout0_14) AT=395.025n

.meas tran vdout0_15ck780 FIND v(dout0_15) AT=395.025n

.meas tran vdout0_16ck780 FIND v(dout0_16) AT=395.025n

.meas tran vdout0_17ck780 FIND v(dout0_17) AT=395.025n

.meas tran vdout0_18ck780 FIND v(dout0_18) AT=395.025n

.meas tran vdout0_19ck780 FIND v(dout0_19) AT=395.025n

.meas tran vdout0_20ck780 FIND v(dout0_20) AT=395.025n

.meas tran vdout0_21ck780 FIND v(dout0_21) AT=395.025n

.meas tran vdout0_22ck780 FIND v(dout0_22) AT=395.025n

.meas tran vdout0_23ck780 FIND v(dout0_23) AT=395.025n

.meas tran vdout0_24ck780 FIND v(dout0_24) AT=395.025n

.meas tran vdout0_25ck780 FIND v(dout0_25) AT=395.025n

.meas tran vdout0_26ck780 FIND v(dout0_26) AT=395.025n

.meas tran vdout0_27ck780 FIND v(dout0_27) AT=395.025n

.meas tran vdout0_28ck780 FIND v(dout0_28) AT=395.025n

.meas tran vdout0_29ck780 FIND v(dout0_29) AT=395.025n

.meas tran vdout0_30ck780 FIND v(dout0_30) AT=395.025n

.meas tran vdout0_31ck780 FIND v(dout0_31) AT=395.025n

.meas tran vdout0_0ck800 FIND v(dout0_0) AT=405.025n

.meas tran vdout0_1ck800 FIND v(dout0_1) AT=405.025n

.meas tran vdout0_2ck800 FIND v(dout0_2) AT=405.025n

.meas tran vdout0_3ck800 FIND v(dout0_3) AT=405.025n

.meas tran vdout0_4ck800 FIND v(dout0_4) AT=405.025n

.meas tran vdout0_5ck800 FIND v(dout0_5) AT=405.025n

.meas tran vdout0_6ck800 FIND v(dout0_6) AT=405.025n

.meas tran vdout0_7ck800 FIND v(dout0_7) AT=405.025n

.meas tran vdout0_8ck800 FIND v(dout0_8) AT=405.025n

.meas tran vdout0_9ck800 FIND v(dout0_9) AT=405.025n

.meas tran vdout0_10ck800 FIND v(dout0_10) AT=405.025n

.meas tran vdout0_11ck800 FIND v(dout0_11) AT=405.025n

.meas tran vdout0_12ck800 FIND v(dout0_12) AT=405.025n

.meas tran vdout0_13ck800 FIND v(dout0_13) AT=405.025n

.meas tran vdout0_14ck800 FIND v(dout0_14) AT=405.025n

.meas tran vdout0_15ck800 FIND v(dout0_15) AT=405.025n

.meas tran vdout0_16ck800 FIND v(dout0_16) AT=405.025n

.meas tran vdout0_17ck800 FIND v(dout0_17) AT=405.025n

.meas tran vdout0_18ck800 FIND v(dout0_18) AT=405.025n

.meas tran vdout0_19ck800 FIND v(dout0_19) AT=405.025n

.meas tran vdout0_20ck800 FIND v(dout0_20) AT=405.025n

.meas tran vdout0_21ck800 FIND v(dout0_21) AT=405.025n

.meas tran vdout0_22ck800 FIND v(dout0_22) AT=405.025n

.meas tran vdout0_23ck800 FIND v(dout0_23) AT=405.025n

.meas tran vdout0_24ck800 FIND v(dout0_24) AT=405.025n

.meas tran vdout0_25ck800 FIND v(dout0_25) AT=405.025n

.meas tran vdout0_26ck800 FIND v(dout0_26) AT=405.025n

.meas tran vdout0_27ck800 FIND v(dout0_27) AT=405.025n

.meas tran vdout0_28ck800 FIND v(dout0_28) AT=405.025n

.meas tran vdout0_29ck800 FIND v(dout0_29) AT=405.025n

.meas tran vdout0_30ck800 FIND v(dout0_30) AT=405.025n

.meas tran vdout0_31ck800 FIND v(dout0_31) AT=405.025n

.meas tran vdout0_0ck820 FIND v(dout0_0) AT=415.025n

.meas tran vdout0_1ck820 FIND v(dout0_1) AT=415.025n

.meas tran vdout0_2ck820 FIND v(dout0_2) AT=415.025n

.meas tran vdout0_3ck820 FIND v(dout0_3) AT=415.025n

.meas tran vdout0_4ck820 FIND v(dout0_4) AT=415.025n

.meas tran vdout0_5ck820 FIND v(dout0_5) AT=415.025n

.meas tran vdout0_6ck820 FIND v(dout0_6) AT=415.025n

.meas tran vdout0_7ck820 FIND v(dout0_7) AT=415.025n

.meas tran vdout0_8ck820 FIND v(dout0_8) AT=415.025n

.meas tran vdout0_9ck820 FIND v(dout0_9) AT=415.025n

.meas tran vdout0_10ck820 FIND v(dout0_10) AT=415.025n

.meas tran vdout0_11ck820 FIND v(dout0_11) AT=415.025n

.meas tran vdout0_12ck820 FIND v(dout0_12) AT=415.025n

.meas tran vdout0_13ck820 FIND v(dout0_13) AT=415.025n

.meas tran vdout0_14ck820 FIND v(dout0_14) AT=415.025n

.meas tran vdout0_15ck820 FIND v(dout0_15) AT=415.025n

.meas tran vdout0_16ck820 FIND v(dout0_16) AT=415.025n

.meas tran vdout0_17ck820 FIND v(dout0_17) AT=415.025n

.meas tran vdout0_18ck820 FIND v(dout0_18) AT=415.025n

.meas tran vdout0_19ck820 FIND v(dout0_19) AT=415.025n

.meas tran vdout0_20ck820 FIND v(dout0_20) AT=415.025n

.meas tran vdout0_21ck820 FIND v(dout0_21) AT=415.025n

.meas tran vdout0_22ck820 FIND v(dout0_22) AT=415.025n

.meas tran vdout0_23ck820 FIND v(dout0_23) AT=415.025n

.meas tran vdout0_24ck820 FIND v(dout0_24) AT=415.025n

.meas tran vdout0_25ck820 FIND v(dout0_25) AT=415.025n

.meas tran vdout0_26ck820 FIND v(dout0_26) AT=415.025n

.meas tran vdout0_27ck820 FIND v(dout0_27) AT=415.025n

.meas tran vdout0_28ck820 FIND v(dout0_28) AT=415.025n

.meas tran vdout0_29ck820 FIND v(dout0_29) AT=415.025n

.meas tran vdout0_30ck820 FIND v(dout0_30) AT=415.025n

.meas tran vdout0_31ck820 FIND v(dout0_31) AT=415.025n

.meas tran vdout0_0ck830 FIND v(dout0_0) AT=420.025n

.meas tran vdout0_1ck830 FIND v(dout0_1) AT=420.025n

.meas tran vdout0_2ck830 FIND v(dout0_2) AT=420.025n

.meas tran vdout0_3ck830 FIND v(dout0_3) AT=420.025n

.meas tran vdout0_4ck830 FIND v(dout0_4) AT=420.025n

.meas tran vdout0_5ck830 FIND v(dout0_5) AT=420.025n

.meas tran vdout0_6ck830 FIND v(dout0_6) AT=420.025n

.meas tran vdout0_7ck830 FIND v(dout0_7) AT=420.025n

.meas tran vdout0_8ck830 FIND v(dout0_8) AT=420.025n

.meas tran vdout0_9ck830 FIND v(dout0_9) AT=420.025n

.meas tran vdout0_10ck830 FIND v(dout0_10) AT=420.025n

.meas tran vdout0_11ck830 FIND v(dout0_11) AT=420.025n

.meas tran vdout0_12ck830 FIND v(dout0_12) AT=420.025n

.meas tran vdout0_13ck830 FIND v(dout0_13) AT=420.025n

.meas tran vdout0_14ck830 FIND v(dout0_14) AT=420.025n

.meas tran vdout0_15ck830 FIND v(dout0_15) AT=420.025n

.meas tran vdout0_16ck830 FIND v(dout0_16) AT=420.025n

.meas tran vdout0_17ck830 FIND v(dout0_17) AT=420.025n

.meas tran vdout0_18ck830 FIND v(dout0_18) AT=420.025n

.meas tran vdout0_19ck830 FIND v(dout0_19) AT=420.025n

.meas tran vdout0_20ck830 FIND v(dout0_20) AT=420.025n

.meas tran vdout0_21ck830 FIND v(dout0_21) AT=420.025n

.meas tran vdout0_22ck830 FIND v(dout0_22) AT=420.025n

.meas tran vdout0_23ck830 FIND v(dout0_23) AT=420.025n

.meas tran vdout0_24ck830 FIND v(dout0_24) AT=420.025n

.meas tran vdout0_25ck830 FIND v(dout0_25) AT=420.025n

.meas tran vdout0_26ck830 FIND v(dout0_26) AT=420.025n

.meas tran vdout0_27ck830 FIND v(dout0_27) AT=420.025n

.meas tran vdout0_28ck830 FIND v(dout0_28) AT=420.025n

.meas tran vdout0_29ck830 FIND v(dout0_29) AT=420.025n

.meas tran vdout0_30ck830 FIND v(dout0_30) AT=420.025n

.meas tran vdout0_31ck830 FIND v(dout0_31) AT=420.025n

.meas tran vdout0_0ck850 FIND v(dout0_0) AT=430.025n

.meas tran vdout0_1ck850 FIND v(dout0_1) AT=430.025n

.meas tran vdout0_2ck850 FIND v(dout0_2) AT=430.025n

.meas tran vdout0_3ck850 FIND v(dout0_3) AT=430.025n

.meas tran vdout0_4ck850 FIND v(dout0_4) AT=430.025n

.meas tran vdout0_5ck850 FIND v(dout0_5) AT=430.025n

.meas tran vdout0_6ck850 FIND v(dout0_6) AT=430.025n

.meas tran vdout0_7ck850 FIND v(dout0_7) AT=430.025n

.meas tran vdout0_8ck850 FIND v(dout0_8) AT=430.025n

.meas tran vdout0_9ck850 FIND v(dout0_9) AT=430.025n

.meas tran vdout0_10ck850 FIND v(dout0_10) AT=430.025n

.meas tran vdout0_11ck850 FIND v(dout0_11) AT=430.025n

.meas tran vdout0_12ck850 FIND v(dout0_12) AT=430.025n

.meas tran vdout0_13ck850 FIND v(dout0_13) AT=430.025n

.meas tran vdout0_14ck850 FIND v(dout0_14) AT=430.025n

.meas tran vdout0_15ck850 FIND v(dout0_15) AT=430.025n

.meas tran vdout0_16ck850 FIND v(dout0_16) AT=430.025n

.meas tran vdout0_17ck850 FIND v(dout0_17) AT=430.025n

.meas tran vdout0_18ck850 FIND v(dout0_18) AT=430.025n

.meas tran vdout0_19ck850 FIND v(dout0_19) AT=430.025n

.meas tran vdout0_20ck850 FIND v(dout0_20) AT=430.025n

.meas tran vdout0_21ck850 FIND v(dout0_21) AT=430.025n

.meas tran vdout0_22ck850 FIND v(dout0_22) AT=430.025n

.meas tran vdout0_23ck850 FIND v(dout0_23) AT=430.025n

.meas tran vdout0_24ck850 FIND v(dout0_24) AT=430.025n

.meas tran vdout0_25ck850 FIND v(dout0_25) AT=430.025n

.meas tran vdout0_26ck850 FIND v(dout0_26) AT=430.025n

.meas tran vdout0_27ck850 FIND v(dout0_27) AT=430.025n

.meas tran vdout0_28ck850 FIND v(dout0_28) AT=430.025n

.meas tran vdout0_29ck850 FIND v(dout0_29) AT=430.025n

.meas tran vdout0_30ck850 FIND v(dout0_30) AT=430.025n

.meas tran vdout0_31ck850 FIND v(dout0_31) AT=430.025n

.meas tran vdout0_0ck860 FIND v(dout0_0) AT=435.025n

.meas tran vdout0_1ck860 FIND v(dout0_1) AT=435.025n

.meas tran vdout0_2ck860 FIND v(dout0_2) AT=435.025n

.meas tran vdout0_3ck860 FIND v(dout0_3) AT=435.025n

.meas tran vdout0_4ck860 FIND v(dout0_4) AT=435.025n

.meas tran vdout0_5ck860 FIND v(dout0_5) AT=435.025n

.meas tran vdout0_6ck860 FIND v(dout0_6) AT=435.025n

.meas tran vdout0_7ck860 FIND v(dout0_7) AT=435.025n

.meas tran vdout0_8ck860 FIND v(dout0_8) AT=435.025n

.meas tran vdout0_9ck860 FIND v(dout0_9) AT=435.025n

.meas tran vdout0_10ck860 FIND v(dout0_10) AT=435.025n

.meas tran vdout0_11ck860 FIND v(dout0_11) AT=435.025n

.meas tran vdout0_12ck860 FIND v(dout0_12) AT=435.025n

.meas tran vdout0_13ck860 FIND v(dout0_13) AT=435.025n

.meas tran vdout0_14ck860 FIND v(dout0_14) AT=435.025n

.meas tran vdout0_15ck860 FIND v(dout0_15) AT=435.025n

.meas tran vdout0_16ck860 FIND v(dout0_16) AT=435.025n

.meas tran vdout0_17ck860 FIND v(dout0_17) AT=435.025n

.meas tran vdout0_18ck860 FIND v(dout0_18) AT=435.025n

.meas tran vdout0_19ck860 FIND v(dout0_19) AT=435.025n

.meas tran vdout0_20ck860 FIND v(dout0_20) AT=435.025n

.meas tran vdout0_21ck860 FIND v(dout0_21) AT=435.025n

.meas tran vdout0_22ck860 FIND v(dout0_22) AT=435.025n

.meas tran vdout0_23ck860 FIND v(dout0_23) AT=435.025n

.meas tran vdout0_24ck860 FIND v(dout0_24) AT=435.025n

.meas tran vdout0_25ck860 FIND v(dout0_25) AT=435.025n

.meas tran vdout0_26ck860 FIND v(dout0_26) AT=435.025n

.meas tran vdout0_27ck860 FIND v(dout0_27) AT=435.025n

.meas tran vdout0_28ck860 FIND v(dout0_28) AT=435.025n

.meas tran vdout0_29ck860 FIND v(dout0_29) AT=435.025n

.meas tran vdout0_30ck860 FIND v(dout0_30) AT=435.025n

.meas tran vdout0_31ck860 FIND v(dout0_31) AT=435.025n

.meas tran vdout0_0ck870 FIND v(dout0_0) AT=440.025n

.meas tran vdout0_1ck870 FIND v(dout0_1) AT=440.025n

.meas tran vdout0_2ck870 FIND v(dout0_2) AT=440.025n

.meas tran vdout0_3ck870 FIND v(dout0_3) AT=440.025n

.meas tran vdout0_4ck870 FIND v(dout0_4) AT=440.025n

.meas tran vdout0_5ck870 FIND v(dout0_5) AT=440.025n

.meas tran vdout0_6ck870 FIND v(dout0_6) AT=440.025n

.meas tran vdout0_7ck870 FIND v(dout0_7) AT=440.025n

.meas tran vdout0_8ck870 FIND v(dout0_8) AT=440.025n

.meas tran vdout0_9ck870 FIND v(dout0_9) AT=440.025n

.meas tran vdout0_10ck870 FIND v(dout0_10) AT=440.025n

.meas tran vdout0_11ck870 FIND v(dout0_11) AT=440.025n

.meas tran vdout0_12ck870 FIND v(dout0_12) AT=440.025n

.meas tran vdout0_13ck870 FIND v(dout0_13) AT=440.025n

.meas tran vdout0_14ck870 FIND v(dout0_14) AT=440.025n

.meas tran vdout0_15ck870 FIND v(dout0_15) AT=440.025n

.meas tran vdout0_16ck870 FIND v(dout0_16) AT=440.025n

.meas tran vdout0_17ck870 FIND v(dout0_17) AT=440.025n

.meas tran vdout0_18ck870 FIND v(dout0_18) AT=440.025n

.meas tran vdout0_19ck870 FIND v(dout0_19) AT=440.025n

.meas tran vdout0_20ck870 FIND v(dout0_20) AT=440.025n

.meas tran vdout0_21ck870 FIND v(dout0_21) AT=440.025n

.meas tran vdout0_22ck870 FIND v(dout0_22) AT=440.025n

.meas tran vdout0_23ck870 FIND v(dout0_23) AT=440.025n

.meas tran vdout0_24ck870 FIND v(dout0_24) AT=440.025n

.meas tran vdout0_25ck870 FIND v(dout0_25) AT=440.025n

.meas tran vdout0_26ck870 FIND v(dout0_26) AT=440.025n

.meas tran vdout0_27ck870 FIND v(dout0_27) AT=440.025n

.meas tran vdout0_28ck870 FIND v(dout0_28) AT=440.025n

.meas tran vdout0_29ck870 FIND v(dout0_29) AT=440.025n

.meas tran vdout0_30ck870 FIND v(dout0_30) AT=440.025n

.meas tran vdout0_31ck870 FIND v(dout0_31) AT=440.025n

.meas tran vdout0_0ck890 FIND v(dout0_0) AT=450.025n

.meas tran vdout0_1ck890 FIND v(dout0_1) AT=450.025n

.meas tran vdout0_2ck890 FIND v(dout0_2) AT=450.025n

.meas tran vdout0_3ck890 FIND v(dout0_3) AT=450.025n

.meas tran vdout0_4ck890 FIND v(dout0_4) AT=450.025n

.meas tran vdout0_5ck890 FIND v(dout0_5) AT=450.025n

.meas tran vdout0_6ck890 FIND v(dout0_6) AT=450.025n

.meas tran vdout0_7ck890 FIND v(dout0_7) AT=450.025n

.meas tran vdout0_8ck890 FIND v(dout0_8) AT=450.025n

.meas tran vdout0_9ck890 FIND v(dout0_9) AT=450.025n

.meas tran vdout0_10ck890 FIND v(dout0_10) AT=450.025n

.meas tran vdout0_11ck890 FIND v(dout0_11) AT=450.025n

.meas tran vdout0_12ck890 FIND v(dout0_12) AT=450.025n

.meas tran vdout0_13ck890 FIND v(dout0_13) AT=450.025n

.meas tran vdout0_14ck890 FIND v(dout0_14) AT=450.025n

.meas tran vdout0_15ck890 FIND v(dout0_15) AT=450.025n

.meas tran vdout0_16ck890 FIND v(dout0_16) AT=450.025n

.meas tran vdout0_17ck890 FIND v(dout0_17) AT=450.025n

.meas tran vdout0_18ck890 FIND v(dout0_18) AT=450.025n

.meas tran vdout0_19ck890 FIND v(dout0_19) AT=450.025n

.meas tran vdout0_20ck890 FIND v(dout0_20) AT=450.025n

.meas tran vdout0_21ck890 FIND v(dout0_21) AT=450.025n

.meas tran vdout0_22ck890 FIND v(dout0_22) AT=450.025n

.meas tran vdout0_23ck890 FIND v(dout0_23) AT=450.025n

.meas tran vdout0_24ck890 FIND v(dout0_24) AT=450.025n

.meas tran vdout0_25ck890 FIND v(dout0_25) AT=450.025n

.meas tran vdout0_26ck890 FIND v(dout0_26) AT=450.025n

.meas tran vdout0_27ck890 FIND v(dout0_27) AT=450.025n

.meas tran vdout0_28ck890 FIND v(dout0_28) AT=450.025n

.meas tran vdout0_29ck890 FIND v(dout0_29) AT=450.025n

.meas tran vdout0_30ck890 FIND v(dout0_30) AT=450.025n

.meas tran vdout0_31ck890 FIND v(dout0_31) AT=450.025n

.meas tran vdout0_0ck900 FIND v(dout0_0) AT=455.025n

.meas tran vdout0_1ck900 FIND v(dout0_1) AT=455.025n

.meas tran vdout0_2ck900 FIND v(dout0_2) AT=455.025n

.meas tran vdout0_3ck900 FIND v(dout0_3) AT=455.025n

.meas tran vdout0_4ck900 FIND v(dout0_4) AT=455.025n

.meas tran vdout0_5ck900 FIND v(dout0_5) AT=455.025n

.meas tran vdout0_6ck900 FIND v(dout0_6) AT=455.025n

.meas tran vdout0_7ck900 FIND v(dout0_7) AT=455.025n

.meas tran vdout0_8ck900 FIND v(dout0_8) AT=455.025n

.meas tran vdout0_9ck900 FIND v(dout0_9) AT=455.025n

.meas tran vdout0_10ck900 FIND v(dout0_10) AT=455.025n

.meas tran vdout0_11ck900 FIND v(dout0_11) AT=455.025n

.meas tran vdout0_12ck900 FIND v(dout0_12) AT=455.025n

.meas tran vdout0_13ck900 FIND v(dout0_13) AT=455.025n

.meas tran vdout0_14ck900 FIND v(dout0_14) AT=455.025n

.meas tran vdout0_15ck900 FIND v(dout0_15) AT=455.025n

.meas tran vdout0_16ck900 FIND v(dout0_16) AT=455.025n

.meas tran vdout0_17ck900 FIND v(dout0_17) AT=455.025n

.meas tran vdout0_18ck900 FIND v(dout0_18) AT=455.025n

.meas tran vdout0_19ck900 FIND v(dout0_19) AT=455.025n

.meas tran vdout0_20ck900 FIND v(dout0_20) AT=455.025n

.meas tran vdout0_21ck900 FIND v(dout0_21) AT=455.025n

.meas tran vdout0_22ck900 FIND v(dout0_22) AT=455.025n

.meas tran vdout0_23ck900 FIND v(dout0_23) AT=455.025n

.meas tran vdout0_24ck900 FIND v(dout0_24) AT=455.025n

.meas tran vdout0_25ck900 FIND v(dout0_25) AT=455.025n

.meas tran vdout0_26ck900 FIND v(dout0_26) AT=455.025n

.meas tran vdout0_27ck900 FIND v(dout0_27) AT=455.025n

.meas tran vdout0_28ck900 FIND v(dout0_28) AT=455.025n

.meas tran vdout0_29ck900 FIND v(dout0_29) AT=455.025n

.meas tran vdout0_30ck900 FIND v(dout0_30) AT=455.025n

.meas tran vdout0_31ck900 FIND v(dout0_31) AT=455.025n

.meas tran vdout0_0ck910 FIND v(dout0_0) AT=460.025n

.meas tran vdout0_1ck910 FIND v(dout0_1) AT=460.025n

.meas tran vdout0_2ck910 FIND v(dout0_2) AT=460.025n

.meas tran vdout0_3ck910 FIND v(dout0_3) AT=460.025n

.meas tran vdout0_4ck910 FIND v(dout0_4) AT=460.025n

.meas tran vdout0_5ck910 FIND v(dout0_5) AT=460.025n

.meas tran vdout0_6ck910 FIND v(dout0_6) AT=460.025n

.meas tran vdout0_7ck910 FIND v(dout0_7) AT=460.025n

.meas tran vdout0_8ck910 FIND v(dout0_8) AT=460.025n

.meas tran vdout0_9ck910 FIND v(dout0_9) AT=460.025n

.meas tran vdout0_10ck910 FIND v(dout0_10) AT=460.025n

.meas tran vdout0_11ck910 FIND v(dout0_11) AT=460.025n

.meas tran vdout0_12ck910 FIND v(dout0_12) AT=460.025n

.meas tran vdout0_13ck910 FIND v(dout0_13) AT=460.025n

.meas tran vdout0_14ck910 FIND v(dout0_14) AT=460.025n

.meas tran vdout0_15ck910 FIND v(dout0_15) AT=460.025n

.meas tran vdout0_16ck910 FIND v(dout0_16) AT=460.025n

.meas tran vdout0_17ck910 FIND v(dout0_17) AT=460.025n

.meas tran vdout0_18ck910 FIND v(dout0_18) AT=460.025n

.meas tran vdout0_19ck910 FIND v(dout0_19) AT=460.025n

.meas tran vdout0_20ck910 FIND v(dout0_20) AT=460.025n

.meas tran vdout0_21ck910 FIND v(dout0_21) AT=460.025n

.meas tran vdout0_22ck910 FIND v(dout0_22) AT=460.025n

.meas tran vdout0_23ck910 FIND v(dout0_23) AT=460.025n

.meas tran vdout0_24ck910 FIND v(dout0_24) AT=460.025n

.meas tran vdout0_25ck910 FIND v(dout0_25) AT=460.025n

.meas tran vdout0_26ck910 FIND v(dout0_26) AT=460.025n

.meas tran vdout0_27ck910 FIND v(dout0_27) AT=460.025n

.meas tran vdout0_28ck910 FIND v(dout0_28) AT=460.025n

.meas tran vdout0_29ck910 FIND v(dout0_29) AT=460.025n

.meas tran vdout0_30ck910 FIND v(dout0_30) AT=460.025n

.meas tran vdout0_31ck910 FIND v(dout0_31) AT=460.025n

.meas tran vdout0_0ck930 FIND v(dout0_0) AT=470.025n

.meas tran vdout0_1ck930 FIND v(dout0_1) AT=470.025n

.meas tran vdout0_2ck930 FIND v(dout0_2) AT=470.025n

.meas tran vdout0_3ck930 FIND v(dout0_3) AT=470.025n

.meas tran vdout0_4ck930 FIND v(dout0_4) AT=470.025n

.meas tran vdout0_5ck930 FIND v(dout0_5) AT=470.025n

.meas tran vdout0_6ck930 FIND v(dout0_6) AT=470.025n

.meas tran vdout0_7ck930 FIND v(dout0_7) AT=470.025n

.meas tran vdout0_8ck930 FIND v(dout0_8) AT=470.025n

.meas tran vdout0_9ck930 FIND v(dout0_9) AT=470.025n

.meas tran vdout0_10ck930 FIND v(dout0_10) AT=470.025n

.meas tran vdout0_11ck930 FIND v(dout0_11) AT=470.025n

.meas tran vdout0_12ck930 FIND v(dout0_12) AT=470.025n

.meas tran vdout0_13ck930 FIND v(dout0_13) AT=470.025n

.meas tran vdout0_14ck930 FIND v(dout0_14) AT=470.025n

.meas tran vdout0_15ck930 FIND v(dout0_15) AT=470.025n

.meas tran vdout0_16ck930 FIND v(dout0_16) AT=470.025n

.meas tran vdout0_17ck930 FIND v(dout0_17) AT=470.025n

.meas tran vdout0_18ck930 FIND v(dout0_18) AT=470.025n

.meas tran vdout0_19ck930 FIND v(dout0_19) AT=470.025n

.meas tran vdout0_20ck930 FIND v(dout0_20) AT=470.025n

.meas tran vdout0_21ck930 FIND v(dout0_21) AT=470.025n

.meas tran vdout0_22ck930 FIND v(dout0_22) AT=470.025n

.meas tran vdout0_23ck930 FIND v(dout0_23) AT=470.025n

.meas tran vdout0_24ck930 FIND v(dout0_24) AT=470.025n

.meas tran vdout0_25ck930 FIND v(dout0_25) AT=470.025n

.meas tran vdout0_26ck930 FIND v(dout0_26) AT=470.025n

.meas tran vdout0_27ck930 FIND v(dout0_27) AT=470.025n

.meas tran vdout0_28ck930 FIND v(dout0_28) AT=470.025n

.meas tran vdout0_29ck930 FIND v(dout0_29) AT=470.025n

.meas tran vdout0_30ck930 FIND v(dout0_30) AT=470.025n

.meas tran vdout0_31ck930 FIND v(dout0_31) AT=470.025n

.meas tran vdout0_0ck960 FIND v(dout0_0) AT=485.025n

.meas tran vdout0_1ck960 FIND v(dout0_1) AT=485.025n

.meas tran vdout0_2ck960 FIND v(dout0_2) AT=485.025n

.meas tran vdout0_3ck960 FIND v(dout0_3) AT=485.025n

.meas tran vdout0_4ck960 FIND v(dout0_4) AT=485.025n

.meas tran vdout0_5ck960 FIND v(dout0_5) AT=485.025n

.meas tran vdout0_6ck960 FIND v(dout0_6) AT=485.025n

.meas tran vdout0_7ck960 FIND v(dout0_7) AT=485.025n

.meas tran vdout0_8ck960 FIND v(dout0_8) AT=485.025n

.meas tran vdout0_9ck960 FIND v(dout0_9) AT=485.025n

.meas tran vdout0_10ck960 FIND v(dout0_10) AT=485.025n

.meas tran vdout0_11ck960 FIND v(dout0_11) AT=485.025n

.meas tran vdout0_12ck960 FIND v(dout0_12) AT=485.025n

.meas tran vdout0_13ck960 FIND v(dout0_13) AT=485.025n

.meas tran vdout0_14ck960 FIND v(dout0_14) AT=485.025n

.meas tran vdout0_15ck960 FIND v(dout0_15) AT=485.025n

.meas tran vdout0_16ck960 FIND v(dout0_16) AT=485.025n

.meas tran vdout0_17ck960 FIND v(dout0_17) AT=485.025n

.meas tran vdout0_18ck960 FIND v(dout0_18) AT=485.025n

.meas tran vdout0_19ck960 FIND v(dout0_19) AT=485.025n

.meas tran vdout0_20ck960 FIND v(dout0_20) AT=485.025n

.meas tran vdout0_21ck960 FIND v(dout0_21) AT=485.025n

.meas tran vdout0_22ck960 FIND v(dout0_22) AT=485.025n

.meas tran vdout0_23ck960 FIND v(dout0_23) AT=485.025n

.meas tran vdout0_24ck960 FIND v(dout0_24) AT=485.025n

.meas tran vdout0_25ck960 FIND v(dout0_25) AT=485.025n

.meas tran vdout0_26ck960 FIND v(dout0_26) AT=485.025n

.meas tran vdout0_27ck960 FIND v(dout0_27) AT=485.025n

.meas tran vdout0_28ck960 FIND v(dout0_28) AT=485.025n

.meas tran vdout0_29ck960 FIND v(dout0_29) AT=485.025n

.meas tran vdout0_30ck960 FIND v(dout0_30) AT=485.025n

.meas tran vdout0_31ck960 FIND v(dout0_31) AT=485.025n

.meas tran vdout0_0ck980 FIND v(dout0_0) AT=495.025n

.meas tran vdout0_1ck980 FIND v(dout0_1) AT=495.025n

.meas tran vdout0_2ck980 FIND v(dout0_2) AT=495.025n

.meas tran vdout0_3ck980 FIND v(dout0_3) AT=495.025n

.meas tran vdout0_4ck980 FIND v(dout0_4) AT=495.025n

.meas tran vdout0_5ck980 FIND v(dout0_5) AT=495.025n

.meas tran vdout0_6ck980 FIND v(dout0_6) AT=495.025n

.meas tran vdout0_7ck980 FIND v(dout0_7) AT=495.025n

.meas tran vdout0_8ck980 FIND v(dout0_8) AT=495.025n

.meas tran vdout0_9ck980 FIND v(dout0_9) AT=495.025n

.meas tran vdout0_10ck980 FIND v(dout0_10) AT=495.025n

.meas tran vdout0_11ck980 FIND v(dout0_11) AT=495.025n

.meas tran vdout0_12ck980 FIND v(dout0_12) AT=495.025n

.meas tran vdout0_13ck980 FIND v(dout0_13) AT=495.025n

.meas tran vdout0_14ck980 FIND v(dout0_14) AT=495.025n

.meas tran vdout0_15ck980 FIND v(dout0_15) AT=495.025n

.meas tran vdout0_16ck980 FIND v(dout0_16) AT=495.025n

.meas tran vdout0_17ck980 FIND v(dout0_17) AT=495.025n

.meas tran vdout0_18ck980 FIND v(dout0_18) AT=495.025n

.meas tran vdout0_19ck980 FIND v(dout0_19) AT=495.025n

.meas tran vdout0_20ck980 FIND v(dout0_20) AT=495.025n

.meas tran vdout0_21ck980 FIND v(dout0_21) AT=495.025n

.meas tran vdout0_22ck980 FIND v(dout0_22) AT=495.025n

.meas tran vdout0_23ck980 FIND v(dout0_23) AT=495.025n

.meas tran vdout0_24ck980 FIND v(dout0_24) AT=495.025n

.meas tran vdout0_25ck980 FIND v(dout0_25) AT=495.025n

.meas tran vdout0_26ck980 FIND v(dout0_26) AT=495.025n

.meas tran vdout0_27ck980 FIND v(dout0_27) AT=495.025n

.meas tran vdout0_28ck980 FIND v(dout0_28) AT=495.025n

.meas tran vdout0_29ck980 FIND v(dout0_29) AT=495.025n

.meas tran vdout0_30ck980 FIND v(dout0_30) AT=495.025n

.meas tran vdout0_31ck980 FIND v(dout0_31) AT=495.025n

.meas tran vdout0_0ck1010 FIND v(dout0_0) AT=510.025n

.meas tran vdout0_1ck1010 FIND v(dout0_1) AT=510.025n

.meas tran vdout0_2ck1010 FIND v(dout0_2) AT=510.025n

.meas tran vdout0_3ck1010 FIND v(dout0_3) AT=510.025n

.meas tran vdout0_4ck1010 FIND v(dout0_4) AT=510.025n

.meas tran vdout0_5ck1010 FIND v(dout0_5) AT=510.025n

.meas tran vdout0_6ck1010 FIND v(dout0_6) AT=510.025n

.meas tran vdout0_7ck1010 FIND v(dout0_7) AT=510.025n

.meas tran vdout0_8ck1010 FIND v(dout0_8) AT=510.025n

.meas tran vdout0_9ck1010 FIND v(dout0_9) AT=510.025n

.meas tran vdout0_10ck1010 FIND v(dout0_10) AT=510.025n

.meas tran vdout0_11ck1010 FIND v(dout0_11) AT=510.025n

.meas tran vdout0_12ck1010 FIND v(dout0_12) AT=510.025n

.meas tran vdout0_13ck1010 FIND v(dout0_13) AT=510.025n

.meas tran vdout0_14ck1010 FIND v(dout0_14) AT=510.025n

.meas tran vdout0_15ck1010 FIND v(dout0_15) AT=510.025n

.meas tran vdout0_16ck1010 FIND v(dout0_16) AT=510.025n

.meas tran vdout0_17ck1010 FIND v(dout0_17) AT=510.025n

.meas tran vdout0_18ck1010 FIND v(dout0_18) AT=510.025n

.meas tran vdout0_19ck1010 FIND v(dout0_19) AT=510.025n

.meas tran vdout0_20ck1010 FIND v(dout0_20) AT=510.025n

.meas tran vdout0_21ck1010 FIND v(dout0_21) AT=510.025n

.meas tran vdout0_22ck1010 FIND v(dout0_22) AT=510.025n

.meas tran vdout0_23ck1010 FIND v(dout0_23) AT=510.025n

.meas tran vdout0_24ck1010 FIND v(dout0_24) AT=510.025n

.meas tran vdout0_25ck1010 FIND v(dout0_25) AT=510.025n

.meas tran vdout0_26ck1010 FIND v(dout0_26) AT=510.025n

.meas tran vdout0_27ck1010 FIND v(dout0_27) AT=510.025n

.meas tran vdout0_28ck1010 FIND v(dout0_28) AT=510.025n

.meas tran vdout0_29ck1010 FIND v(dout0_29) AT=510.025n

.meas tran vdout0_30ck1010 FIND v(dout0_30) AT=510.025n

.meas tran vdout0_31ck1010 FIND v(dout0_31) AT=510.025n

.meas tran vdout0_0ck1020 FIND v(dout0_0) AT=515.025n

.meas tran vdout0_1ck1020 FIND v(dout0_1) AT=515.025n

.meas tran vdout0_2ck1020 FIND v(dout0_2) AT=515.025n

.meas tran vdout0_3ck1020 FIND v(dout0_3) AT=515.025n

.meas tran vdout0_4ck1020 FIND v(dout0_4) AT=515.025n

.meas tran vdout0_5ck1020 FIND v(dout0_5) AT=515.025n

.meas tran vdout0_6ck1020 FIND v(dout0_6) AT=515.025n

.meas tran vdout0_7ck1020 FIND v(dout0_7) AT=515.025n

.meas tran vdout0_8ck1020 FIND v(dout0_8) AT=515.025n

.meas tran vdout0_9ck1020 FIND v(dout0_9) AT=515.025n

.meas tran vdout0_10ck1020 FIND v(dout0_10) AT=515.025n

.meas tran vdout0_11ck1020 FIND v(dout0_11) AT=515.025n

.meas tran vdout0_12ck1020 FIND v(dout0_12) AT=515.025n

.meas tran vdout0_13ck1020 FIND v(dout0_13) AT=515.025n

.meas tran vdout0_14ck1020 FIND v(dout0_14) AT=515.025n

.meas tran vdout0_15ck1020 FIND v(dout0_15) AT=515.025n

.meas tran vdout0_16ck1020 FIND v(dout0_16) AT=515.025n

.meas tran vdout0_17ck1020 FIND v(dout0_17) AT=515.025n

.meas tran vdout0_18ck1020 FIND v(dout0_18) AT=515.025n

.meas tran vdout0_19ck1020 FIND v(dout0_19) AT=515.025n

.meas tran vdout0_20ck1020 FIND v(dout0_20) AT=515.025n

.meas tran vdout0_21ck1020 FIND v(dout0_21) AT=515.025n

.meas tran vdout0_22ck1020 FIND v(dout0_22) AT=515.025n

.meas tran vdout0_23ck1020 FIND v(dout0_23) AT=515.025n

.meas tran vdout0_24ck1020 FIND v(dout0_24) AT=515.025n

.meas tran vdout0_25ck1020 FIND v(dout0_25) AT=515.025n

.meas tran vdout0_26ck1020 FIND v(dout0_26) AT=515.025n

.meas tran vdout0_27ck1020 FIND v(dout0_27) AT=515.025n

.meas tran vdout0_28ck1020 FIND v(dout0_28) AT=515.025n

.meas tran vdout0_29ck1020 FIND v(dout0_29) AT=515.025n

.meas tran vdout0_30ck1020 FIND v(dout0_30) AT=515.025n

.meas tran vdout0_31ck1020 FIND v(dout0_31) AT=515.025n

.meas tran vdout0_0ck1060 FIND v(dout0_0) AT=535.025n

.meas tran vdout0_1ck1060 FIND v(dout0_1) AT=535.025n

.meas tran vdout0_2ck1060 FIND v(dout0_2) AT=535.025n

.meas tran vdout0_3ck1060 FIND v(dout0_3) AT=535.025n

.meas tran vdout0_4ck1060 FIND v(dout0_4) AT=535.025n

.meas tran vdout0_5ck1060 FIND v(dout0_5) AT=535.025n

.meas tran vdout0_6ck1060 FIND v(dout0_6) AT=535.025n

.meas tran vdout0_7ck1060 FIND v(dout0_7) AT=535.025n

.meas tran vdout0_8ck1060 FIND v(dout0_8) AT=535.025n

.meas tran vdout0_9ck1060 FIND v(dout0_9) AT=535.025n

.meas tran vdout0_10ck1060 FIND v(dout0_10) AT=535.025n

.meas tran vdout0_11ck1060 FIND v(dout0_11) AT=535.025n

.meas tran vdout0_12ck1060 FIND v(dout0_12) AT=535.025n

.meas tran vdout0_13ck1060 FIND v(dout0_13) AT=535.025n

.meas tran vdout0_14ck1060 FIND v(dout0_14) AT=535.025n

.meas tran vdout0_15ck1060 FIND v(dout0_15) AT=535.025n

.meas tran vdout0_16ck1060 FIND v(dout0_16) AT=535.025n

.meas tran vdout0_17ck1060 FIND v(dout0_17) AT=535.025n

.meas tran vdout0_18ck1060 FIND v(dout0_18) AT=535.025n

.meas tran vdout0_19ck1060 FIND v(dout0_19) AT=535.025n

.meas tran vdout0_20ck1060 FIND v(dout0_20) AT=535.025n

.meas tran vdout0_21ck1060 FIND v(dout0_21) AT=535.025n

.meas tran vdout0_22ck1060 FIND v(dout0_22) AT=535.025n

.meas tran vdout0_23ck1060 FIND v(dout0_23) AT=535.025n

.meas tran vdout0_24ck1060 FIND v(dout0_24) AT=535.025n

.meas tran vdout0_25ck1060 FIND v(dout0_25) AT=535.025n

.meas tran vdout0_26ck1060 FIND v(dout0_26) AT=535.025n

.meas tran vdout0_27ck1060 FIND v(dout0_27) AT=535.025n

.meas tran vdout0_28ck1060 FIND v(dout0_28) AT=535.025n

.meas tran vdout0_29ck1060 FIND v(dout0_29) AT=535.025n

.meas tran vdout0_30ck1060 FIND v(dout0_30) AT=535.025n

.meas tran vdout0_31ck1060 FIND v(dout0_31) AT=535.025n

.meas tran vdout0_0ck1080 FIND v(dout0_0) AT=545.025n

.meas tran vdout0_1ck1080 FIND v(dout0_1) AT=545.025n

.meas tran vdout0_2ck1080 FIND v(dout0_2) AT=545.025n

.meas tran vdout0_3ck1080 FIND v(dout0_3) AT=545.025n

.meas tran vdout0_4ck1080 FIND v(dout0_4) AT=545.025n

.meas tran vdout0_5ck1080 FIND v(dout0_5) AT=545.025n

.meas tran vdout0_6ck1080 FIND v(dout0_6) AT=545.025n

.meas tran vdout0_7ck1080 FIND v(dout0_7) AT=545.025n

.meas tran vdout0_8ck1080 FIND v(dout0_8) AT=545.025n

.meas tran vdout0_9ck1080 FIND v(dout0_9) AT=545.025n

.meas tran vdout0_10ck1080 FIND v(dout0_10) AT=545.025n

.meas tran vdout0_11ck1080 FIND v(dout0_11) AT=545.025n

.meas tran vdout0_12ck1080 FIND v(dout0_12) AT=545.025n

.meas tran vdout0_13ck1080 FIND v(dout0_13) AT=545.025n

.meas tran vdout0_14ck1080 FIND v(dout0_14) AT=545.025n

.meas tran vdout0_15ck1080 FIND v(dout0_15) AT=545.025n

.meas tran vdout0_16ck1080 FIND v(dout0_16) AT=545.025n

.meas tran vdout0_17ck1080 FIND v(dout0_17) AT=545.025n

.meas tran vdout0_18ck1080 FIND v(dout0_18) AT=545.025n

.meas tran vdout0_19ck1080 FIND v(dout0_19) AT=545.025n

.meas tran vdout0_20ck1080 FIND v(dout0_20) AT=545.025n

.meas tran vdout0_21ck1080 FIND v(dout0_21) AT=545.025n

.meas tran vdout0_22ck1080 FIND v(dout0_22) AT=545.025n

.meas tran vdout0_23ck1080 FIND v(dout0_23) AT=545.025n

.meas tran vdout0_24ck1080 FIND v(dout0_24) AT=545.025n

.meas tran vdout0_25ck1080 FIND v(dout0_25) AT=545.025n

.meas tran vdout0_26ck1080 FIND v(dout0_26) AT=545.025n

.meas tran vdout0_27ck1080 FIND v(dout0_27) AT=545.025n

.meas tran vdout0_28ck1080 FIND v(dout0_28) AT=545.025n

.meas tran vdout0_29ck1080 FIND v(dout0_29) AT=545.025n

.meas tran vdout0_30ck1080 FIND v(dout0_30) AT=545.025n

.meas tran vdout0_31ck1080 FIND v(dout0_31) AT=545.025n

.meas tran vdout0_0ck1090 FIND v(dout0_0) AT=550.025n

.meas tran vdout0_1ck1090 FIND v(dout0_1) AT=550.025n

.meas tran vdout0_2ck1090 FIND v(dout0_2) AT=550.025n

.meas tran vdout0_3ck1090 FIND v(dout0_3) AT=550.025n

.meas tran vdout0_4ck1090 FIND v(dout0_4) AT=550.025n

.meas tran vdout0_5ck1090 FIND v(dout0_5) AT=550.025n

.meas tran vdout0_6ck1090 FIND v(dout0_6) AT=550.025n

.meas tran vdout0_7ck1090 FIND v(dout0_7) AT=550.025n

.meas tran vdout0_8ck1090 FIND v(dout0_8) AT=550.025n

.meas tran vdout0_9ck1090 FIND v(dout0_9) AT=550.025n

.meas tran vdout0_10ck1090 FIND v(dout0_10) AT=550.025n

.meas tran vdout0_11ck1090 FIND v(dout0_11) AT=550.025n

.meas tran vdout0_12ck1090 FIND v(dout0_12) AT=550.025n

.meas tran vdout0_13ck1090 FIND v(dout0_13) AT=550.025n

.meas tran vdout0_14ck1090 FIND v(dout0_14) AT=550.025n

.meas tran vdout0_15ck1090 FIND v(dout0_15) AT=550.025n

.meas tran vdout0_16ck1090 FIND v(dout0_16) AT=550.025n

.meas tran vdout0_17ck1090 FIND v(dout0_17) AT=550.025n

.meas tran vdout0_18ck1090 FIND v(dout0_18) AT=550.025n

.meas tran vdout0_19ck1090 FIND v(dout0_19) AT=550.025n

.meas tran vdout0_20ck1090 FIND v(dout0_20) AT=550.025n

.meas tran vdout0_21ck1090 FIND v(dout0_21) AT=550.025n

.meas tran vdout0_22ck1090 FIND v(dout0_22) AT=550.025n

.meas tran vdout0_23ck1090 FIND v(dout0_23) AT=550.025n

.meas tran vdout0_24ck1090 FIND v(dout0_24) AT=550.025n

.meas tran vdout0_25ck1090 FIND v(dout0_25) AT=550.025n

.meas tran vdout0_26ck1090 FIND v(dout0_26) AT=550.025n

.meas tran vdout0_27ck1090 FIND v(dout0_27) AT=550.025n

.meas tran vdout0_28ck1090 FIND v(dout0_28) AT=550.025n

.meas tran vdout0_29ck1090 FIND v(dout0_29) AT=550.025n

.meas tran vdout0_30ck1090 FIND v(dout0_30) AT=550.025n

.meas tran vdout0_31ck1090 FIND v(dout0_31) AT=550.025n

.meas tran vdout0_0ck1100 FIND v(dout0_0) AT=555.025n

.meas tran vdout0_1ck1100 FIND v(dout0_1) AT=555.025n

.meas tran vdout0_2ck1100 FIND v(dout0_2) AT=555.025n

.meas tran vdout0_3ck1100 FIND v(dout0_3) AT=555.025n

.meas tran vdout0_4ck1100 FIND v(dout0_4) AT=555.025n

.meas tran vdout0_5ck1100 FIND v(dout0_5) AT=555.025n

.meas tran vdout0_6ck1100 FIND v(dout0_6) AT=555.025n

.meas tran vdout0_7ck1100 FIND v(dout0_7) AT=555.025n

.meas tran vdout0_8ck1100 FIND v(dout0_8) AT=555.025n

.meas tran vdout0_9ck1100 FIND v(dout0_9) AT=555.025n

.meas tran vdout0_10ck1100 FIND v(dout0_10) AT=555.025n

.meas tran vdout0_11ck1100 FIND v(dout0_11) AT=555.025n

.meas tran vdout0_12ck1100 FIND v(dout0_12) AT=555.025n

.meas tran vdout0_13ck1100 FIND v(dout0_13) AT=555.025n

.meas tran vdout0_14ck1100 FIND v(dout0_14) AT=555.025n

.meas tran vdout0_15ck1100 FIND v(dout0_15) AT=555.025n

.meas tran vdout0_16ck1100 FIND v(dout0_16) AT=555.025n

.meas tran vdout0_17ck1100 FIND v(dout0_17) AT=555.025n

.meas tran vdout0_18ck1100 FIND v(dout0_18) AT=555.025n

.meas tran vdout0_19ck1100 FIND v(dout0_19) AT=555.025n

.meas tran vdout0_20ck1100 FIND v(dout0_20) AT=555.025n

.meas tran vdout0_21ck1100 FIND v(dout0_21) AT=555.025n

.meas tran vdout0_22ck1100 FIND v(dout0_22) AT=555.025n

.meas tran vdout0_23ck1100 FIND v(dout0_23) AT=555.025n

.meas tran vdout0_24ck1100 FIND v(dout0_24) AT=555.025n

.meas tran vdout0_25ck1100 FIND v(dout0_25) AT=555.025n

.meas tran vdout0_26ck1100 FIND v(dout0_26) AT=555.025n

.meas tran vdout0_27ck1100 FIND v(dout0_27) AT=555.025n

.meas tran vdout0_28ck1100 FIND v(dout0_28) AT=555.025n

.meas tran vdout0_29ck1100 FIND v(dout0_29) AT=555.025n

.meas tran vdout0_30ck1100 FIND v(dout0_30) AT=555.025n

.meas tran vdout0_31ck1100 FIND v(dout0_31) AT=555.025n

.meas tran vdout0_0ck1110 FIND v(dout0_0) AT=560.025n

.meas tran vdout0_1ck1110 FIND v(dout0_1) AT=560.025n

.meas tran vdout0_2ck1110 FIND v(dout0_2) AT=560.025n

.meas tran vdout0_3ck1110 FIND v(dout0_3) AT=560.025n

.meas tran vdout0_4ck1110 FIND v(dout0_4) AT=560.025n

.meas tran vdout0_5ck1110 FIND v(dout0_5) AT=560.025n

.meas tran vdout0_6ck1110 FIND v(dout0_6) AT=560.025n

.meas tran vdout0_7ck1110 FIND v(dout0_7) AT=560.025n

.meas tran vdout0_8ck1110 FIND v(dout0_8) AT=560.025n

.meas tran vdout0_9ck1110 FIND v(dout0_9) AT=560.025n

.meas tran vdout0_10ck1110 FIND v(dout0_10) AT=560.025n

.meas tran vdout0_11ck1110 FIND v(dout0_11) AT=560.025n

.meas tran vdout0_12ck1110 FIND v(dout0_12) AT=560.025n

.meas tran vdout0_13ck1110 FIND v(dout0_13) AT=560.025n

.meas tran vdout0_14ck1110 FIND v(dout0_14) AT=560.025n

.meas tran vdout0_15ck1110 FIND v(dout0_15) AT=560.025n

.meas tran vdout0_16ck1110 FIND v(dout0_16) AT=560.025n

.meas tran vdout0_17ck1110 FIND v(dout0_17) AT=560.025n

.meas tran vdout0_18ck1110 FIND v(dout0_18) AT=560.025n

.meas tran vdout0_19ck1110 FIND v(dout0_19) AT=560.025n

.meas tran vdout0_20ck1110 FIND v(dout0_20) AT=560.025n

.meas tran vdout0_21ck1110 FIND v(dout0_21) AT=560.025n

.meas tran vdout0_22ck1110 FIND v(dout0_22) AT=560.025n

.meas tran vdout0_23ck1110 FIND v(dout0_23) AT=560.025n

.meas tran vdout0_24ck1110 FIND v(dout0_24) AT=560.025n

.meas tran vdout0_25ck1110 FIND v(dout0_25) AT=560.025n

.meas tran vdout0_26ck1110 FIND v(dout0_26) AT=560.025n

.meas tran vdout0_27ck1110 FIND v(dout0_27) AT=560.025n

.meas tran vdout0_28ck1110 FIND v(dout0_28) AT=560.025n

.meas tran vdout0_29ck1110 FIND v(dout0_29) AT=560.025n

.meas tran vdout0_30ck1110 FIND v(dout0_30) AT=560.025n

.meas tran vdout0_31ck1110 FIND v(dout0_31) AT=560.025n

.meas tran vdout0_0ck1120 FIND v(dout0_0) AT=565.025n

.meas tran vdout0_1ck1120 FIND v(dout0_1) AT=565.025n

.meas tran vdout0_2ck1120 FIND v(dout0_2) AT=565.025n

.meas tran vdout0_3ck1120 FIND v(dout0_3) AT=565.025n

.meas tran vdout0_4ck1120 FIND v(dout0_4) AT=565.025n

.meas tran vdout0_5ck1120 FIND v(dout0_5) AT=565.025n

.meas tran vdout0_6ck1120 FIND v(dout0_6) AT=565.025n

.meas tran vdout0_7ck1120 FIND v(dout0_7) AT=565.025n

.meas tran vdout0_8ck1120 FIND v(dout0_8) AT=565.025n

.meas tran vdout0_9ck1120 FIND v(dout0_9) AT=565.025n

.meas tran vdout0_10ck1120 FIND v(dout0_10) AT=565.025n

.meas tran vdout0_11ck1120 FIND v(dout0_11) AT=565.025n

.meas tran vdout0_12ck1120 FIND v(dout0_12) AT=565.025n

.meas tran vdout0_13ck1120 FIND v(dout0_13) AT=565.025n

.meas tran vdout0_14ck1120 FIND v(dout0_14) AT=565.025n

.meas tran vdout0_15ck1120 FIND v(dout0_15) AT=565.025n

.meas tran vdout0_16ck1120 FIND v(dout0_16) AT=565.025n

.meas tran vdout0_17ck1120 FIND v(dout0_17) AT=565.025n

.meas tran vdout0_18ck1120 FIND v(dout0_18) AT=565.025n

.meas tran vdout0_19ck1120 FIND v(dout0_19) AT=565.025n

.meas tran vdout0_20ck1120 FIND v(dout0_20) AT=565.025n

.meas tran vdout0_21ck1120 FIND v(dout0_21) AT=565.025n

.meas tran vdout0_22ck1120 FIND v(dout0_22) AT=565.025n

.meas tran vdout0_23ck1120 FIND v(dout0_23) AT=565.025n

.meas tran vdout0_24ck1120 FIND v(dout0_24) AT=565.025n

.meas tran vdout0_25ck1120 FIND v(dout0_25) AT=565.025n

.meas tran vdout0_26ck1120 FIND v(dout0_26) AT=565.025n

.meas tran vdout0_27ck1120 FIND v(dout0_27) AT=565.025n

.meas tran vdout0_28ck1120 FIND v(dout0_28) AT=565.025n

.meas tran vdout0_29ck1120 FIND v(dout0_29) AT=565.025n

.meas tran vdout0_30ck1120 FIND v(dout0_30) AT=565.025n

.meas tran vdout0_31ck1120 FIND v(dout0_31) AT=565.025n

.meas tran vdout0_0ck1130 FIND v(dout0_0) AT=570.025n

.meas tran vdout0_1ck1130 FIND v(dout0_1) AT=570.025n

.meas tran vdout0_2ck1130 FIND v(dout0_2) AT=570.025n

.meas tran vdout0_3ck1130 FIND v(dout0_3) AT=570.025n

.meas tran vdout0_4ck1130 FIND v(dout0_4) AT=570.025n

.meas tran vdout0_5ck1130 FIND v(dout0_5) AT=570.025n

.meas tran vdout0_6ck1130 FIND v(dout0_6) AT=570.025n

.meas tran vdout0_7ck1130 FIND v(dout0_7) AT=570.025n

.meas tran vdout0_8ck1130 FIND v(dout0_8) AT=570.025n

.meas tran vdout0_9ck1130 FIND v(dout0_9) AT=570.025n

.meas tran vdout0_10ck1130 FIND v(dout0_10) AT=570.025n

.meas tran vdout0_11ck1130 FIND v(dout0_11) AT=570.025n

.meas tran vdout0_12ck1130 FIND v(dout0_12) AT=570.025n

.meas tran vdout0_13ck1130 FIND v(dout0_13) AT=570.025n

.meas tran vdout0_14ck1130 FIND v(dout0_14) AT=570.025n

.meas tran vdout0_15ck1130 FIND v(dout0_15) AT=570.025n

.meas tran vdout0_16ck1130 FIND v(dout0_16) AT=570.025n

.meas tran vdout0_17ck1130 FIND v(dout0_17) AT=570.025n

.meas tran vdout0_18ck1130 FIND v(dout0_18) AT=570.025n

.meas tran vdout0_19ck1130 FIND v(dout0_19) AT=570.025n

.meas tran vdout0_20ck1130 FIND v(dout0_20) AT=570.025n

.meas tran vdout0_21ck1130 FIND v(dout0_21) AT=570.025n

.meas tran vdout0_22ck1130 FIND v(dout0_22) AT=570.025n

.meas tran vdout0_23ck1130 FIND v(dout0_23) AT=570.025n

.meas tran vdout0_24ck1130 FIND v(dout0_24) AT=570.025n

.meas tran vdout0_25ck1130 FIND v(dout0_25) AT=570.025n

.meas tran vdout0_26ck1130 FIND v(dout0_26) AT=570.025n

.meas tran vdout0_27ck1130 FIND v(dout0_27) AT=570.025n

.meas tran vdout0_28ck1130 FIND v(dout0_28) AT=570.025n

.meas tran vdout0_29ck1130 FIND v(dout0_29) AT=570.025n

.meas tran vdout0_30ck1130 FIND v(dout0_30) AT=570.025n

.meas tran vdout0_31ck1130 FIND v(dout0_31) AT=570.025n

.meas tran vdout0_0ck1140 FIND v(dout0_0) AT=575.025n

.meas tran vdout0_1ck1140 FIND v(dout0_1) AT=575.025n

.meas tran vdout0_2ck1140 FIND v(dout0_2) AT=575.025n

.meas tran vdout0_3ck1140 FIND v(dout0_3) AT=575.025n

.meas tran vdout0_4ck1140 FIND v(dout0_4) AT=575.025n

.meas tran vdout0_5ck1140 FIND v(dout0_5) AT=575.025n

.meas tran vdout0_6ck1140 FIND v(dout0_6) AT=575.025n

.meas tran vdout0_7ck1140 FIND v(dout0_7) AT=575.025n

.meas tran vdout0_8ck1140 FIND v(dout0_8) AT=575.025n

.meas tran vdout0_9ck1140 FIND v(dout0_9) AT=575.025n

.meas tran vdout0_10ck1140 FIND v(dout0_10) AT=575.025n

.meas tran vdout0_11ck1140 FIND v(dout0_11) AT=575.025n

.meas tran vdout0_12ck1140 FIND v(dout0_12) AT=575.025n

.meas tran vdout0_13ck1140 FIND v(dout0_13) AT=575.025n

.meas tran vdout0_14ck1140 FIND v(dout0_14) AT=575.025n

.meas tran vdout0_15ck1140 FIND v(dout0_15) AT=575.025n

.meas tran vdout0_16ck1140 FIND v(dout0_16) AT=575.025n

.meas tran vdout0_17ck1140 FIND v(dout0_17) AT=575.025n

.meas tran vdout0_18ck1140 FIND v(dout0_18) AT=575.025n

.meas tran vdout0_19ck1140 FIND v(dout0_19) AT=575.025n

.meas tran vdout0_20ck1140 FIND v(dout0_20) AT=575.025n

.meas tran vdout0_21ck1140 FIND v(dout0_21) AT=575.025n

.meas tran vdout0_22ck1140 FIND v(dout0_22) AT=575.025n

.meas tran vdout0_23ck1140 FIND v(dout0_23) AT=575.025n

.meas tran vdout0_24ck1140 FIND v(dout0_24) AT=575.025n

.meas tran vdout0_25ck1140 FIND v(dout0_25) AT=575.025n

.meas tran vdout0_26ck1140 FIND v(dout0_26) AT=575.025n

.meas tran vdout0_27ck1140 FIND v(dout0_27) AT=575.025n

.meas tran vdout0_28ck1140 FIND v(dout0_28) AT=575.025n

.meas tran vdout0_29ck1140 FIND v(dout0_29) AT=575.025n

.meas tran vdout0_30ck1140 FIND v(dout0_30) AT=575.025n

.meas tran vdout0_31ck1140 FIND v(dout0_31) AT=575.025n

.meas tran vdout0_0ck1150 FIND v(dout0_0) AT=580.025n

.meas tran vdout0_1ck1150 FIND v(dout0_1) AT=580.025n

.meas tran vdout0_2ck1150 FIND v(dout0_2) AT=580.025n

.meas tran vdout0_3ck1150 FIND v(dout0_3) AT=580.025n

.meas tran vdout0_4ck1150 FIND v(dout0_4) AT=580.025n

.meas tran vdout0_5ck1150 FIND v(dout0_5) AT=580.025n

.meas tran vdout0_6ck1150 FIND v(dout0_6) AT=580.025n

.meas tran vdout0_7ck1150 FIND v(dout0_7) AT=580.025n

.meas tran vdout0_8ck1150 FIND v(dout0_8) AT=580.025n

.meas tran vdout0_9ck1150 FIND v(dout0_9) AT=580.025n

.meas tran vdout0_10ck1150 FIND v(dout0_10) AT=580.025n

.meas tran vdout0_11ck1150 FIND v(dout0_11) AT=580.025n

.meas tran vdout0_12ck1150 FIND v(dout0_12) AT=580.025n

.meas tran vdout0_13ck1150 FIND v(dout0_13) AT=580.025n

.meas tran vdout0_14ck1150 FIND v(dout0_14) AT=580.025n

.meas tran vdout0_15ck1150 FIND v(dout0_15) AT=580.025n

.meas tran vdout0_16ck1150 FIND v(dout0_16) AT=580.025n

.meas tran vdout0_17ck1150 FIND v(dout0_17) AT=580.025n

.meas tran vdout0_18ck1150 FIND v(dout0_18) AT=580.025n

.meas tran vdout0_19ck1150 FIND v(dout0_19) AT=580.025n

.meas tran vdout0_20ck1150 FIND v(dout0_20) AT=580.025n

.meas tran vdout0_21ck1150 FIND v(dout0_21) AT=580.025n

.meas tran vdout0_22ck1150 FIND v(dout0_22) AT=580.025n

.meas tran vdout0_23ck1150 FIND v(dout0_23) AT=580.025n

.meas tran vdout0_24ck1150 FIND v(dout0_24) AT=580.025n

.meas tran vdout0_25ck1150 FIND v(dout0_25) AT=580.025n

.meas tran vdout0_26ck1150 FIND v(dout0_26) AT=580.025n

.meas tran vdout0_27ck1150 FIND v(dout0_27) AT=580.025n

.meas tran vdout0_28ck1150 FIND v(dout0_28) AT=580.025n

.meas tran vdout0_29ck1150 FIND v(dout0_29) AT=580.025n

.meas tran vdout0_30ck1150 FIND v(dout0_30) AT=580.025n

.meas tran vdout0_31ck1150 FIND v(dout0_31) AT=580.025n

.meas tran vdout0_0ck1160 FIND v(dout0_0) AT=585.025n

.meas tran vdout0_1ck1160 FIND v(dout0_1) AT=585.025n

.meas tran vdout0_2ck1160 FIND v(dout0_2) AT=585.025n

.meas tran vdout0_3ck1160 FIND v(dout0_3) AT=585.025n

.meas tran vdout0_4ck1160 FIND v(dout0_4) AT=585.025n

.meas tran vdout0_5ck1160 FIND v(dout0_5) AT=585.025n

.meas tran vdout0_6ck1160 FIND v(dout0_6) AT=585.025n

.meas tran vdout0_7ck1160 FIND v(dout0_7) AT=585.025n

.meas tran vdout0_8ck1160 FIND v(dout0_8) AT=585.025n

.meas tran vdout0_9ck1160 FIND v(dout0_9) AT=585.025n

.meas tran vdout0_10ck1160 FIND v(dout0_10) AT=585.025n

.meas tran vdout0_11ck1160 FIND v(dout0_11) AT=585.025n

.meas tran vdout0_12ck1160 FIND v(dout0_12) AT=585.025n

.meas tran vdout0_13ck1160 FIND v(dout0_13) AT=585.025n

.meas tran vdout0_14ck1160 FIND v(dout0_14) AT=585.025n

.meas tran vdout0_15ck1160 FIND v(dout0_15) AT=585.025n

.meas tran vdout0_16ck1160 FIND v(dout0_16) AT=585.025n

.meas tran vdout0_17ck1160 FIND v(dout0_17) AT=585.025n

.meas tran vdout0_18ck1160 FIND v(dout0_18) AT=585.025n

.meas tran vdout0_19ck1160 FIND v(dout0_19) AT=585.025n

.meas tran vdout0_20ck1160 FIND v(dout0_20) AT=585.025n

.meas tran vdout0_21ck1160 FIND v(dout0_21) AT=585.025n

.meas tran vdout0_22ck1160 FIND v(dout0_22) AT=585.025n

.meas tran vdout0_23ck1160 FIND v(dout0_23) AT=585.025n

.meas tran vdout0_24ck1160 FIND v(dout0_24) AT=585.025n

.meas tran vdout0_25ck1160 FIND v(dout0_25) AT=585.025n

.meas tran vdout0_26ck1160 FIND v(dout0_26) AT=585.025n

.meas tran vdout0_27ck1160 FIND v(dout0_27) AT=585.025n

.meas tran vdout0_28ck1160 FIND v(dout0_28) AT=585.025n

.meas tran vdout0_29ck1160 FIND v(dout0_29) AT=585.025n

.meas tran vdout0_30ck1160 FIND v(dout0_30) AT=585.025n

.meas tran vdout0_31ck1160 FIND v(dout0_31) AT=585.025n

.meas tran vdout0_0ck1170 FIND v(dout0_0) AT=590.025n

.meas tran vdout0_1ck1170 FIND v(dout0_1) AT=590.025n

.meas tran vdout0_2ck1170 FIND v(dout0_2) AT=590.025n

.meas tran vdout0_3ck1170 FIND v(dout0_3) AT=590.025n

.meas tran vdout0_4ck1170 FIND v(dout0_4) AT=590.025n

.meas tran vdout0_5ck1170 FIND v(dout0_5) AT=590.025n

.meas tran vdout0_6ck1170 FIND v(dout0_6) AT=590.025n

.meas tran vdout0_7ck1170 FIND v(dout0_7) AT=590.025n

.meas tran vdout0_8ck1170 FIND v(dout0_8) AT=590.025n

.meas tran vdout0_9ck1170 FIND v(dout0_9) AT=590.025n

.meas tran vdout0_10ck1170 FIND v(dout0_10) AT=590.025n

.meas tran vdout0_11ck1170 FIND v(dout0_11) AT=590.025n

.meas tran vdout0_12ck1170 FIND v(dout0_12) AT=590.025n

.meas tran vdout0_13ck1170 FIND v(dout0_13) AT=590.025n

.meas tran vdout0_14ck1170 FIND v(dout0_14) AT=590.025n

.meas tran vdout0_15ck1170 FIND v(dout0_15) AT=590.025n

.meas tran vdout0_16ck1170 FIND v(dout0_16) AT=590.025n

.meas tran vdout0_17ck1170 FIND v(dout0_17) AT=590.025n

.meas tran vdout0_18ck1170 FIND v(dout0_18) AT=590.025n

.meas tran vdout0_19ck1170 FIND v(dout0_19) AT=590.025n

.meas tran vdout0_20ck1170 FIND v(dout0_20) AT=590.025n

.meas tran vdout0_21ck1170 FIND v(dout0_21) AT=590.025n

.meas tran vdout0_22ck1170 FIND v(dout0_22) AT=590.025n

.meas tran vdout0_23ck1170 FIND v(dout0_23) AT=590.025n

.meas tran vdout0_24ck1170 FIND v(dout0_24) AT=590.025n

.meas tran vdout0_25ck1170 FIND v(dout0_25) AT=590.025n

.meas tran vdout0_26ck1170 FIND v(dout0_26) AT=590.025n

.meas tran vdout0_27ck1170 FIND v(dout0_27) AT=590.025n

.meas tran vdout0_28ck1170 FIND v(dout0_28) AT=590.025n

.meas tran vdout0_29ck1170 FIND v(dout0_29) AT=590.025n

.meas tran vdout0_30ck1170 FIND v(dout0_30) AT=590.025n

.meas tran vdout0_31ck1170 FIND v(dout0_31) AT=590.025n

.meas tran vdout0_0ck1180 FIND v(dout0_0) AT=595.025n

.meas tran vdout0_1ck1180 FIND v(dout0_1) AT=595.025n

.meas tran vdout0_2ck1180 FIND v(dout0_2) AT=595.025n

.meas tran vdout0_3ck1180 FIND v(dout0_3) AT=595.025n

.meas tran vdout0_4ck1180 FIND v(dout0_4) AT=595.025n

.meas tran vdout0_5ck1180 FIND v(dout0_5) AT=595.025n

.meas tran vdout0_6ck1180 FIND v(dout0_6) AT=595.025n

.meas tran vdout0_7ck1180 FIND v(dout0_7) AT=595.025n

.meas tran vdout0_8ck1180 FIND v(dout0_8) AT=595.025n

.meas tran vdout0_9ck1180 FIND v(dout0_9) AT=595.025n

.meas tran vdout0_10ck1180 FIND v(dout0_10) AT=595.025n

.meas tran vdout0_11ck1180 FIND v(dout0_11) AT=595.025n

.meas tran vdout0_12ck1180 FIND v(dout0_12) AT=595.025n

.meas tran vdout0_13ck1180 FIND v(dout0_13) AT=595.025n

.meas tran vdout0_14ck1180 FIND v(dout0_14) AT=595.025n

.meas tran vdout0_15ck1180 FIND v(dout0_15) AT=595.025n

.meas tran vdout0_16ck1180 FIND v(dout0_16) AT=595.025n

.meas tran vdout0_17ck1180 FIND v(dout0_17) AT=595.025n

.meas tran vdout0_18ck1180 FIND v(dout0_18) AT=595.025n

.meas tran vdout0_19ck1180 FIND v(dout0_19) AT=595.025n

.meas tran vdout0_20ck1180 FIND v(dout0_20) AT=595.025n

.meas tran vdout0_21ck1180 FIND v(dout0_21) AT=595.025n

.meas tran vdout0_22ck1180 FIND v(dout0_22) AT=595.025n

.meas tran vdout0_23ck1180 FIND v(dout0_23) AT=595.025n

.meas tran vdout0_24ck1180 FIND v(dout0_24) AT=595.025n

.meas tran vdout0_25ck1180 FIND v(dout0_25) AT=595.025n

.meas tran vdout0_26ck1180 FIND v(dout0_26) AT=595.025n

.meas tran vdout0_27ck1180 FIND v(dout0_27) AT=595.025n

.meas tran vdout0_28ck1180 FIND v(dout0_28) AT=595.025n

.meas tran vdout0_29ck1180 FIND v(dout0_29) AT=595.025n

.meas tran vdout0_30ck1180 FIND v(dout0_30) AT=595.025n

.meas tran vdout0_31ck1180 FIND v(dout0_31) AT=595.025n

.meas tran vdout0_0ck1210 FIND v(dout0_0) AT=610.025n

.meas tran vdout0_1ck1210 FIND v(dout0_1) AT=610.025n

.meas tran vdout0_2ck1210 FIND v(dout0_2) AT=610.025n

.meas tran vdout0_3ck1210 FIND v(dout0_3) AT=610.025n

.meas tran vdout0_4ck1210 FIND v(dout0_4) AT=610.025n

.meas tran vdout0_5ck1210 FIND v(dout0_5) AT=610.025n

.meas tran vdout0_6ck1210 FIND v(dout0_6) AT=610.025n

.meas tran vdout0_7ck1210 FIND v(dout0_7) AT=610.025n

.meas tran vdout0_8ck1210 FIND v(dout0_8) AT=610.025n

.meas tran vdout0_9ck1210 FIND v(dout0_9) AT=610.025n

.meas tran vdout0_10ck1210 FIND v(dout0_10) AT=610.025n

.meas tran vdout0_11ck1210 FIND v(dout0_11) AT=610.025n

.meas tran vdout0_12ck1210 FIND v(dout0_12) AT=610.025n

.meas tran vdout0_13ck1210 FIND v(dout0_13) AT=610.025n

.meas tran vdout0_14ck1210 FIND v(dout0_14) AT=610.025n

.meas tran vdout0_15ck1210 FIND v(dout0_15) AT=610.025n

.meas tran vdout0_16ck1210 FIND v(dout0_16) AT=610.025n

.meas tran vdout0_17ck1210 FIND v(dout0_17) AT=610.025n

.meas tran vdout0_18ck1210 FIND v(dout0_18) AT=610.025n

.meas tran vdout0_19ck1210 FIND v(dout0_19) AT=610.025n

.meas tran vdout0_20ck1210 FIND v(dout0_20) AT=610.025n

.meas tran vdout0_21ck1210 FIND v(dout0_21) AT=610.025n

.meas tran vdout0_22ck1210 FIND v(dout0_22) AT=610.025n

.meas tran vdout0_23ck1210 FIND v(dout0_23) AT=610.025n

.meas tran vdout0_24ck1210 FIND v(dout0_24) AT=610.025n

.meas tran vdout0_25ck1210 FIND v(dout0_25) AT=610.025n

.meas tran vdout0_26ck1210 FIND v(dout0_26) AT=610.025n

.meas tran vdout0_27ck1210 FIND v(dout0_27) AT=610.025n

.meas tran vdout0_28ck1210 FIND v(dout0_28) AT=610.025n

.meas tran vdout0_29ck1210 FIND v(dout0_29) AT=610.025n

.meas tran vdout0_30ck1210 FIND v(dout0_30) AT=610.025n

.meas tran vdout0_31ck1210 FIND v(dout0_31) AT=610.025n

.meas tran vdout0_0ck1250 FIND v(dout0_0) AT=630.025n

.meas tran vdout0_1ck1250 FIND v(dout0_1) AT=630.025n

.meas tran vdout0_2ck1250 FIND v(dout0_2) AT=630.025n

.meas tran vdout0_3ck1250 FIND v(dout0_3) AT=630.025n

.meas tran vdout0_4ck1250 FIND v(dout0_4) AT=630.025n

.meas tran vdout0_5ck1250 FIND v(dout0_5) AT=630.025n

.meas tran vdout0_6ck1250 FIND v(dout0_6) AT=630.025n

.meas tran vdout0_7ck1250 FIND v(dout0_7) AT=630.025n

.meas tran vdout0_8ck1250 FIND v(dout0_8) AT=630.025n

.meas tran vdout0_9ck1250 FIND v(dout0_9) AT=630.025n

.meas tran vdout0_10ck1250 FIND v(dout0_10) AT=630.025n

.meas tran vdout0_11ck1250 FIND v(dout0_11) AT=630.025n

.meas tran vdout0_12ck1250 FIND v(dout0_12) AT=630.025n

.meas tran vdout0_13ck1250 FIND v(dout0_13) AT=630.025n

.meas tran vdout0_14ck1250 FIND v(dout0_14) AT=630.025n

.meas tran vdout0_15ck1250 FIND v(dout0_15) AT=630.025n

.meas tran vdout0_16ck1250 FIND v(dout0_16) AT=630.025n

.meas tran vdout0_17ck1250 FIND v(dout0_17) AT=630.025n

.meas tran vdout0_18ck1250 FIND v(dout0_18) AT=630.025n

.meas tran vdout0_19ck1250 FIND v(dout0_19) AT=630.025n

.meas tran vdout0_20ck1250 FIND v(dout0_20) AT=630.025n

.meas tran vdout0_21ck1250 FIND v(dout0_21) AT=630.025n

.meas tran vdout0_22ck1250 FIND v(dout0_22) AT=630.025n

.meas tran vdout0_23ck1250 FIND v(dout0_23) AT=630.025n

.meas tran vdout0_24ck1250 FIND v(dout0_24) AT=630.025n

.meas tran vdout0_25ck1250 FIND v(dout0_25) AT=630.025n

.meas tran vdout0_26ck1250 FIND v(dout0_26) AT=630.025n

.meas tran vdout0_27ck1250 FIND v(dout0_27) AT=630.025n

.meas tran vdout0_28ck1250 FIND v(dout0_28) AT=630.025n

.meas tran vdout0_29ck1250 FIND v(dout0_29) AT=630.025n

.meas tran vdout0_30ck1250 FIND v(dout0_30) AT=630.025n

.meas tran vdout0_31ck1250 FIND v(dout0_31) AT=630.025n

.meas tran vdout0_0ck1280 FIND v(dout0_0) AT=645.025n

.meas tran vdout0_1ck1280 FIND v(dout0_1) AT=645.025n

.meas tran vdout0_2ck1280 FIND v(dout0_2) AT=645.025n

.meas tran vdout0_3ck1280 FIND v(dout0_3) AT=645.025n

.meas tran vdout0_4ck1280 FIND v(dout0_4) AT=645.025n

.meas tran vdout0_5ck1280 FIND v(dout0_5) AT=645.025n

.meas tran vdout0_6ck1280 FIND v(dout0_6) AT=645.025n

.meas tran vdout0_7ck1280 FIND v(dout0_7) AT=645.025n

.meas tran vdout0_8ck1280 FIND v(dout0_8) AT=645.025n

.meas tran vdout0_9ck1280 FIND v(dout0_9) AT=645.025n

.meas tran vdout0_10ck1280 FIND v(dout0_10) AT=645.025n

.meas tran vdout0_11ck1280 FIND v(dout0_11) AT=645.025n

.meas tran vdout0_12ck1280 FIND v(dout0_12) AT=645.025n

.meas tran vdout0_13ck1280 FIND v(dout0_13) AT=645.025n

.meas tran vdout0_14ck1280 FIND v(dout0_14) AT=645.025n

.meas tran vdout0_15ck1280 FIND v(dout0_15) AT=645.025n

.meas tran vdout0_16ck1280 FIND v(dout0_16) AT=645.025n

.meas tran vdout0_17ck1280 FIND v(dout0_17) AT=645.025n

.meas tran vdout0_18ck1280 FIND v(dout0_18) AT=645.025n

.meas tran vdout0_19ck1280 FIND v(dout0_19) AT=645.025n

.meas tran vdout0_20ck1280 FIND v(dout0_20) AT=645.025n

.meas tran vdout0_21ck1280 FIND v(dout0_21) AT=645.025n

.meas tran vdout0_22ck1280 FIND v(dout0_22) AT=645.025n

.meas tran vdout0_23ck1280 FIND v(dout0_23) AT=645.025n

.meas tran vdout0_24ck1280 FIND v(dout0_24) AT=645.025n

.meas tran vdout0_25ck1280 FIND v(dout0_25) AT=645.025n

.meas tran vdout0_26ck1280 FIND v(dout0_26) AT=645.025n

.meas tran vdout0_27ck1280 FIND v(dout0_27) AT=645.025n

.meas tran vdout0_28ck1280 FIND v(dout0_28) AT=645.025n

.meas tran vdout0_29ck1280 FIND v(dout0_29) AT=645.025n

.meas tran vdout0_30ck1280 FIND v(dout0_30) AT=645.025n

.meas tran vdout0_31ck1280 FIND v(dout0_31) AT=645.025n

.meas tran vdout0_0ck1300 FIND v(dout0_0) AT=655.025n

.meas tran vdout0_1ck1300 FIND v(dout0_1) AT=655.025n

.meas tran vdout0_2ck1300 FIND v(dout0_2) AT=655.025n

.meas tran vdout0_3ck1300 FIND v(dout0_3) AT=655.025n

.meas tran vdout0_4ck1300 FIND v(dout0_4) AT=655.025n

.meas tran vdout0_5ck1300 FIND v(dout0_5) AT=655.025n

.meas tran vdout0_6ck1300 FIND v(dout0_6) AT=655.025n

.meas tran vdout0_7ck1300 FIND v(dout0_7) AT=655.025n

.meas tran vdout0_8ck1300 FIND v(dout0_8) AT=655.025n

.meas tran vdout0_9ck1300 FIND v(dout0_9) AT=655.025n

.meas tran vdout0_10ck1300 FIND v(dout0_10) AT=655.025n

.meas tran vdout0_11ck1300 FIND v(dout0_11) AT=655.025n

.meas tran vdout0_12ck1300 FIND v(dout0_12) AT=655.025n

.meas tran vdout0_13ck1300 FIND v(dout0_13) AT=655.025n

.meas tran vdout0_14ck1300 FIND v(dout0_14) AT=655.025n

.meas tran vdout0_15ck1300 FIND v(dout0_15) AT=655.025n

.meas tran vdout0_16ck1300 FIND v(dout0_16) AT=655.025n

.meas tran vdout0_17ck1300 FIND v(dout0_17) AT=655.025n

.meas tran vdout0_18ck1300 FIND v(dout0_18) AT=655.025n

.meas tran vdout0_19ck1300 FIND v(dout0_19) AT=655.025n

.meas tran vdout0_20ck1300 FIND v(dout0_20) AT=655.025n

.meas tran vdout0_21ck1300 FIND v(dout0_21) AT=655.025n

.meas tran vdout0_22ck1300 FIND v(dout0_22) AT=655.025n

.meas tran vdout0_23ck1300 FIND v(dout0_23) AT=655.025n

.meas tran vdout0_24ck1300 FIND v(dout0_24) AT=655.025n

.meas tran vdout0_25ck1300 FIND v(dout0_25) AT=655.025n

.meas tran vdout0_26ck1300 FIND v(dout0_26) AT=655.025n

.meas tran vdout0_27ck1300 FIND v(dout0_27) AT=655.025n

.meas tran vdout0_28ck1300 FIND v(dout0_28) AT=655.025n

.meas tran vdout0_29ck1300 FIND v(dout0_29) AT=655.025n

.meas tran vdout0_30ck1300 FIND v(dout0_30) AT=655.025n

.meas tran vdout0_31ck1300 FIND v(dout0_31) AT=655.025n

.meas tran vdout0_0ck1310 FIND v(dout0_0) AT=660.025n

.meas tran vdout0_1ck1310 FIND v(dout0_1) AT=660.025n

.meas tran vdout0_2ck1310 FIND v(dout0_2) AT=660.025n

.meas tran vdout0_3ck1310 FIND v(dout0_3) AT=660.025n

.meas tran vdout0_4ck1310 FIND v(dout0_4) AT=660.025n

.meas tran vdout0_5ck1310 FIND v(dout0_5) AT=660.025n

.meas tran vdout0_6ck1310 FIND v(dout0_6) AT=660.025n

.meas tran vdout0_7ck1310 FIND v(dout0_7) AT=660.025n

.meas tran vdout0_8ck1310 FIND v(dout0_8) AT=660.025n

.meas tran vdout0_9ck1310 FIND v(dout0_9) AT=660.025n

.meas tran vdout0_10ck1310 FIND v(dout0_10) AT=660.025n

.meas tran vdout0_11ck1310 FIND v(dout0_11) AT=660.025n

.meas tran vdout0_12ck1310 FIND v(dout0_12) AT=660.025n

.meas tran vdout0_13ck1310 FIND v(dout0_13) AT=660.025n

.meas tran vdout0_14ck1310 FIND v(dout0_14) AT=660.025n

.meas tran vdout0_15ck1310 FIND v(dout0_15) AT=660.025n

.meas tran vdout0_16ck1310 FIND v(dout0_16) AT=660.025n

.meas tran vdout0_17ck1310 FIND v(dout0_17) AT=660.025n

.meas tran vdout0_18ck1310 FIND v(dout0_18) AT=660.025n

.meas tran vdout0_19ck1310 FIND v(dout0_19) AT=660.025n

.meas tran vdout0_20ck1310 FIND v(dout0_20) AT=660.025n

.meas tran vdout0_21ck1310 FIND v(dout0_21) AT=660.025n

.meas tran vdout0_22ck1310 FIND v(dout0_22) AT=660.025n

.meas tran vdout0_23ck1310 FIND v(dout0_23) AT=660.025n

.meas tran vdout0_24ck1310 FIND v(dout0_24) AT=660.025n

.meas tran vdout0_25ck1310 FIND v(dout0_25) AT=660.025n

.meas tran vdout0_26ck1310 FIND v(dout0_26) AT=660.025n

.meas tran vdout0_27ck1310 FIND v(dout0_27) AT=660.025n

.meas tran vdout0_28ck1310 FIND v(dout0_28) AT=660.025n

.meas tran vdout0_29ck1310 FIND v(dout0_29) AT=660.025n

.meas tran vdout0_30ck1310 FIND v(dout0_30) AT=660.025n

.meas tran vdout0_31ck1310 FIND v(dout0_31) AT=660.025n

.meas tran vdout0_0ck1340 FIND v(dout0_0) AT=675.025n

.meas tran vdout0_1ck1340 FIND v(dout0_1) AT=675.025n

.meas tran vdout0_2ck1340 FIND v(dout0_2) AT=675.025n

.meas tran vdout0_3ck1340 FIND v(dout0_3) AT=675.025n

.meas tran vdout0_4ck1340 FIND v(dout0_4) AT=675.025n

.meas tran vdout0_5ck1340 FIND v(dout0_5) AT=675.025n

.meas tran vdout0_6ck1340 FIND v(dout0_6) AT=675.025n

.meas tran vdout0_7ck1340 FIND v(dout0_7) AT=675.025n

.meas tran vdout0_8ck1340 FIND v(dout0_8) AT=675.025n

.meas tran vdout0_9ck1340 FIND v(dout0_9) AT=675.025n

.meas tran vdout0_10ck1340 FIND v(dout0_10) AT=675.025n

.meas tran vdout0_11ck1340 FIND v(dout0_11) AT=675.025n

.meas tran vdout0_12ck1340 FIND v(dout0_12) AT=675.025n

.meas tran vdout0_13ck1340 FIND v(dout0_13) AT=675.025n

.meas tran vdout0_14ck1340 FIND v(dout0_14) AT=675.025n

.meas tran vdout0_15ck1340 FIND v(dout0_15) AT=675.025n

.meas tran vdout0_16ck1340 FIND v(dout0_16) AT=675.025n

.meas tran vdout0_17ck1340 FIND v(dout0_17) AT=675.025n

.meas tran vdout0_18ck1340 FIND v(dout0_18) AT=675.025n

.meas tran vdout0_19ck1340 FIND v(dout0_19) AT=675.025n

.meas tran vdout0_20ck1340 FIND v(dout0_20) AT=675.025n

.meas tran vdout0_21ck1340 FIND v(dout0_21) AT=675.025n

.meas tran vdout0_22ck1340 FIND v(dout0_22) AT=675.025n

.meas tran vdout0_23ck1340 FIND v(dout0_23) AT=675.025n

.meas tran vdout0_24ck1340 FIND v(dout0_24) AT=675.025n

.meas tran vdout0_25ck1340 FIND v(dout0_25) AT=675.025n

.meas tran vdout0_26ck1340 FIND v(dout0_26) AT=675.025n

.meas tran vdout0_27ck1340 FIND v(dout0_27) AT=675.025n

.meas tran vdout0_28ck1340 FIND v(dout0_28) AT=675.025n

.meas tran vdout0_29ck1340 FIND v(dout0_29) AT=675.025n

.meas tran vdout0_30ck1340 FIND v(dout0_30) AT=675.025n

.meas tran vdout0_31ck1340 FIND v(dout0_31) AT=675.025n

.meas tran vdout0_0ck1370 FIND v(dout0_0) AT=690.025n

.meas tran vdout0_1ck1370 FIND v(dout0_1) AT=690.025n

.meas tran vdout0_2ck1370 FIND v(dout0_2) AT=690.025n

.meas tran vdout0_3ck1370 FIND v(dout0_3) AT=690.025n

.meas tran vdout0_4ck1370 FIND v(dout0_4) AT=690.025n

.meas tran vdout0_5ck1370 FIND v(dout0_5) AT=690.025n

.meas tran vdout0_6ck1370 FIND v(dout0_6) AT=690.025n

.meas tran vdout0_7ck1370 FIND v(dout0_7) AT=690.025n

.meas tran vdout0_8ck1370 FIND v(dout0_8) AT=690.025n

.meas tran vdout0_9ck1370 FIND v(dout0_9) AT=690.025n

.meas tran vdout0_10ck1370 FIND v(dout0_10) AT=690.025n

.meas tran vdout0_11ck1370 FIND v(dout0_11) AT=690.025n

.meas tran vdout0_12ck1370 FIND v(dout0_12) AT=690.025n

.meas tran vdout0_13ck1370 FIND v(dout0_13) AT=690.025n

.meas tran vdout0_14ck1370 FIND v(dout0_14) AT=690.025n

.meas tran vdout0_15ck1370 FIND v(dout0_15) AT=690.025n

.meas tran vdout0_16ck1370 FIND v(dout0_16) AT=690.025n

.meas tran vdout0_17ck1370 FIND v(dout0_17) AT=690.025n

.meas tran vdout0_18ck1370 FIND v(dout0_18) AT=690.025n

.meas tran vdout0_19ck1370 FIND v(dout0_19) AT=690.025n

.meas tran vdout0_20ck1370 FIND v(dout0_20) AT=690.025n

.meas tran vdout0_21ck1370 FIND v(dout0_21) AT=690.025n

.meas tran vdout0_22ck1370 FIND v(dout0_22) AT=690.025n

.meas tran vdout0_23ck1370 FIND v(dout0_23) AT=690.025n

.meas tran vdout0_24ck1370 FIND v(dout0_24) AT=690.025n

.meas tran vdout0_25ck1370 FIND v(dout0_25) AT=690.025n

.meas tran vdout0_26ck1370 FIND v(dout0_26) AT=690.025n

.meas tran vdout0_27ck1370 FIND v(dout0_27) AT=690.025n

.meas tran vdout0_28ck1370 FIND v(dout0_28) AT=690.025n

.meas tran vdout0_29ck1370 FIND v(dout0_29) AT=690.025n

.meas tran vdout0_30ck1370 FIND v(dout0_30) AT=690.025n

.meas tran vdout0_31ck1370 FIND v(dout0_31) AT=690.025n

.meas tran vdout0_0ck1380 FIND v(dout0_0) AT=695.025n

.meas tran vdout0_1ck1380 FIND v(dout0_1) AT=695.025n

.meas tran vdout0_2ck1380 FIND v(dout0_2) AT=695.025n

.meas tran vdout0_3ck1380 FIND v(dout0_3) AT=695.025n

.meas tran vdout0_4ck1380 FIND v(dout0_4) AT=695.025n

.meas tran vdout0_5ck1380 FIND v(dout0_5) AT=695.025n

.meas tran vdout0_6ck1380 FIND v(dout0_6) AT=695.025n

.meas tran vdout0_7ck1380 FIND v(dout0_7) AT=695.025n

.meas tran vdout0_8ck1380 FIND v(dout0_8) AT=695.025n

.meas tran vdout0_9ck1380 FIND v(dout0_9) AT=695.025n

.meas tran vdout0_10ck1380 FIND v(dout0_10) AT=695.025n

.meas tran vdout0_11ck1380 FIND v(dout0_11) AT=695.025n

.meas tran vdout0_12ck1380 FIND v(dout0_12) AT=695.025n

.meas tran vdout0_13ck1380 FIND v(dout0_13) AT=695.025n

.meas tran vdout0_14ck1380 FIND v(dout0_14) AT=695.025n

.meas tran vdout0_15ck1380 FIND v(dout0_15) AT=695.025n

.meas tran vdout0_16ck1380 FIND v(dout0_16) AT=695.025n

.meas tran vdout0_17ck1380 FIND v(dout0_17) AT=695.025n

.meas tran vdout0_18ck1380 FIND v(dout0_18) AT=695.025n

.meas tran vdout0_19ck1380 FIND v(dout0_19) AT=695.025n

.meas tran vdout0_20ck1380 FIND v(dout0_20) AT=695.025n

.meas tran vdout0_21ck1380 FIND v(dout0_21) AT=695.025n

.meas tran vdout0_22ck1380 FIND v(dout0_22) AT=695.025n

.meas tran vdout0_23ck1380 FIND v(dout0_23) AT=695.025n

.meas tran vdout0_24ck1380 FIND v(dout0_24) AT=695.025n

.meas tran vdout0_25ck1380 FIND v(dout0_25) AT=695.025n

.meas tran vdout0_26ck1380 FIND v(dout0_26) AT=695.025n

.meas tran vdout0_27ck1380 FIND v(dout0_27) AT=695.025n

.meas tran vdout0_28ck1380 FIND v(dout0_28) AT=695.025n

.meas tran vdout0_29ck1380 FIND v(dout0_29) AT=695.025n

.meas tran vdout0_30ck1380 FIND v(dout0_30) AT=695.025n

.meas tran vdout0_31ck1380 FIND v(dout0_31) AT=695.025n

.meas tran vdout0_0ck1390 FIND v(dout0_0) AT=700.025n

.meas tran vdout0_1ck1390 FIND v(dout0_1) AT=700.025n

.meas tran vdout0_2ck1390 FIND v(dout0_2) AT=700.025n

.meas tran vdout0_3ck1390 FIND v(dout0_3) AT=700.025n

.meas tran vdout0_4ck1390 FIND v(dout0_4) AT=700.025n

.meas tran vdout0_5ck1390 FIND v(dout0_5) AT=700.025n

.meas tran vdout0_6ck1390 FIND v(dout0_6) AT=700.025n

.meas tran vdout0_7ck1390 FIND v(dout0_7) AT=700.025n

.meas tran vdout0_8ck1390 FIND v(dout0_8) AT=700.025n

.meas tran vdout0_9ck1390 FIND v(dout0_9) AT=700.025n

.meas tran vdout0_10ck1390 FIND v(dout0_10) AT=700.025n

.meas tran vdout0_11ck1390 FIND v(dout0_11) AT=700.025n

.meas tran vdout0_12ck1390 FIND v(dout0_12) AT=700.025n

.meas tran vdout0_13ck1390 FIND v(dout0_13) AT=700.025n

.meas tran vdout0_14ck1390 FIND v(dout0_14) AT=700.025n

.meas tran vdout0_15ck1390 FIND v(dout0_15) AT=700.025n

.meas tran vdout0_16ck1390 FIND v(dout0_16) AT=700.025n

.meas tran vdout0_17ck1390 FIND v(dout0_17) AT=700.025n

.meas tran vdout0_18ck1390 FIND v(dout0_18) AT=700.025n

.meas tran vdout0_19ck1390 FIND v(dout0_19) AT=700.025n

.meas tran vdout0_20ck1390 FIND v(dout0_20) AT=700.025n

.meas tran vdout0_21ck1390 FIND v(dout0_21) AT=700.025n

.meas tran vdout0_22ck1390 FIND v(dout0_22) AT=700.025n

.meas tran vdout0_23ck1390 FIND v(dout0_23) AT=700.025n

.meas tran vdout0_24ck1390 FIND v(dout0_24) AT=700.025n

.meas tran vdout0_25ck1390 FIND v(dout0_25) AT=700.025n

.meas tran vdout0_26ck1390 FIND v(dout0_26) AT=700.025n

.meas tran vdout0_27ck1390 FIND v(dout0_27) AT=700.025n

.meas tran vdout0_28ck1390 FIND v(dout0_28) AT=700.025n

.meas tran vdout0_29ck1390 FIND v(dout0_29) AT=700.025n

.meas tran vdout0_30ck1390 FIND v(dout0_30) AT=700.025n

.meas tran vdout0_31ck1390 FIND v(dout0_31) AT=700.025n

.meas tran vdout0_0ck1410 FIND v(dout0_0) AT=710.025n

.meas tran vdout0_1ck1410 FIND v(dout0_1) AT=710.025n

.meas tran vdout0_2ck1410 FIND v(dout0_2) AT=710.025n

.meas tran vdout0_3ck1410 FIND v(dout0_3) AT=710.025n

.meas tran vdout0_4ck1410 FIND v(dout0_4) AT=710.025n

.meas tran vdout0_5ck1410 FIND v(dout0_5) AT=710.025n

.meas tran vdout0_6ck1410 FIND v(dout0_6) AT=710.025n

.meas tran vdout0_7ck1410 FIND v(dout0_7) AT=710.025n

.meas tran vdout0_8ck1410 FIND v(dout0_8) AT=710.025n

.meas tran vdout0_9ck1410 FIND v(dout0_9) AT=710.025n

.meas tran vdout0_10ck1410 FIND v(dout0_10) AT=710.025n

.meas tran vdout0_11ck1410 FIND v(dout0_11) AT=710.025n

.meas tran vdout0_12ck1410 FIND v(dout0_12) AT=710.025n

.meas tran vdout0_13ck1410 FIND v(dout0_13) AT=710.025n

.meas tran vdout0_14ck1410 FIND v(dout0_14) AT=710.025n

.meas tran vdout0_15ck1410 FIND v(dout0_15) AT=710.025n

.meas tran vdout0_16ck1410 FIND v(dout0_16) AT=710.025n

.meas tran vdout0_17ck1410 FIND v(dout0_17) AT=710.025n

.meas tran vdout0_18ck1410 FIND v(dout0_18) AT=710.025n

.meas tran vdout0_19ck1410 FIND v(dout0_19) AT=710.025n

.meas tran vdout0_20ck1410 FIND v(dout0_20) AT=710.025n

.meas tran vdout0_21ck1410 FIND v(dout0_21) AT=710.025n

.meas tran vdout0_22ck1410 FIND v(dout0_22) AT=710.025n

.meas tran vdout0_23ck1410 FIND v(dout0_23) AT=710.025n

.meas tran vdout0_24ck1410 FIND v(dout0_24) AT=710.025n

.meas tran vdout0_25ck1410 FIND v(dout0_25) AT=710.025n

.meas tran vdout0_26ck1410 FIND v(dout0_26) AT=710.025n

.meas tran vdout0_27ck1410 FIND v(dout0_27) AT=710.025n

.meas tran vdout0_28ck1410 FIND v(dout0_28) AT=710.025n

.meas tran vdout0_29ck1410 FIND v(dout0_29) AT=710.025n

.meas tran vdout0_30ck1410 FIND v(dout0_30) AT=710.025n

.meas tran vdout0_31ck1410 FIND v(dout0_31) AT=710.025n

.meas tran vdout0_0ck1440 FIND v(dout0_0) AT=725.025n

.meas tran vdout0_1ck1440 FIND v(dout0_1) AT=725.025n

.meas tran vdout0_2ck1440 FIND v(dout0_2) AT=725.025n

.meas tran vdout0_3ck1440 FIND v(dout0_3) AT=725.025n

.meas tran vdout0_4ck1440 FIND v(dout0_4) AT=725.025n

.meas tran vdout0_5ck1440 FIND v(dout0_5) AT=725.025n

.meas tran vdout0_6ck1440 FIND v(dout0_6) AT=725.025n

.meas tran vdout0_7ck1440 FIND v(dout0_7) AT=725.025n

.meas tran vdout0_8ck1440 FIND v(dout0_8) AT=725.025n

.meas tran vdout0_9ck1440 FIND v(dout0_9) AT=725.025n

.meas tran vdout0_10ck1440 FIND v(dout0_10) AT=725.025n

.meas tran vdout0_11ck1440 FIND v(dout0_11) AT=725.025n

.meas tran vdout0_12ck1440 FIND v(dout0_12) AT=725.025n

.meas tran vdout0_13ck1440 FIND v(dout0_13) AT=725.025n

.meas tran vdout0_14ck1440 FIND v(dout0_14) AT=725.025n

.meas tran vdout0_15ck1440 FIND v(dout0_15) AT=725.025n

.meas tran vdout0_16ck1440 FIND v(dout0_16) AT=725.025n

.meas tran vdout0_17ck1440 FIND v(dout0_17) AT=725.025n

.meas tran vdout0_18ck1440 FIND v(dout0_18) AT=725.025n

.meas tran vdout0_19ck1440 FIND v(dout0_19) AT=725.025n

.meas tran vdout0_20ck1440 FIND v(dout0_20) AT=725.025n

.meas tran vdout0_21ck1440 FIND v(dout0_21) AT=725.025n

.meas tran vdout0_22ck1440 FIND v(dout0_22) AT=725.025n

.meas tran vdout0_23ck1440 FIND v(dout0_23) AT=725.025n

.meas tran vdout0_24ck1440 FIND v(dout0_24) AT=725.025n

.meas tran vdout0_25ck1440 FIND v(dout0_25) AT=725.025n

.meas tran vdout0_26ck1440 FIND v(dout0_26) AT=725.025n

.meas tran vdout0_27ck1440 FIND v(dout0_27) AT=725.025n

.meas tran vdout0_28ck1440 FIND v(dout0_28) AT=725.025n

.meas tran vdout0_29ck1440 FIND v(dout0_29) AT=725.025n

.meas tran vdout0_30ck1440 FIND v(dout0_30) AT=725.025n

.meas tran vdout0_31ck1440 FIND v(dout0_31) AT=725.025n

.meas tran vdout0_0ck1460 FIND v(dout0_0) AT=735.025n

.meas tran vdout0_1ck1460 FIND v(dout0_1) AT=735.025n

.meas tran vdout0_2ck1460 FIND v(dout0_2) AT=735.025n

.meas tran vdout0_3ck1460 FIND v(dout0_3) AT=735.025n

.meas tran vdout0_4ck1460 FIND v(dout0_4) AT=735.025n

.meas tran vdout0_5ck1460 FIND v(dout0_5) AT=735.025n

.meas tran vdout0_6ck1460 FIND v(dout0_6) AT=735.025n

.meas tran vdout0_7ck1460 FIND v(dout0_7) AT=735.025n

.meas tran vdout0_8ck1460 FIND v(dout0_8) AT=735.025n

.meas tran vdout0_9ck1460 FIND v(dout0_9) AT=735.025n

.meas tran vdout0_10ck1460 FIND v(dout0_10) AT=735.025n

.meas tran vdout0_11ck1460 FIND v(dout0_11) AT=735.025n

.meas tran vdout0_12ck1460 FIND v(dout0_12) AT=735.025n

.meas tran vdout0_13ck1460 FIND v(dout0_13) AT=735.025n

.meas tran vdout0_14ck1460 FIND v(dout0_14) AT=735.025n

.meas tran vdout0_15ck1460 FIND v(dout0_15) AT=735.025n

.meas tran vdout0_16ck1460 FIND v(dout0_16) AT=735.025n

.meas tran vdout0_17ck1460 FIND v(dout0_17) AT=735.025n

.meas tran vdout0_18ck1460 FIND v(dout0_18) AT=735.025n

.meas tran vdout0_19ck1460 FIND v(dout0_19) AT=735.025n

.meas tran vdout0_20ck1460 FIND v(dout0_20) AT=735.025n

.meas tran vdout0_21ck1460 FIND v(dout0_21) AT=735.025n

.meas tran vdout0_22ck1460 FIND v(dout0_22) AT=735.025n

.meas tran vdout0_23ck1460 FIND v(dout0_23) AT=735.025n

.meas tran vdout0_24ck1460 FIND v(dout0_24) AT=735.025n

.meas tran vdout0_25ck1460 FIND v(dout0_25) AT=735.025n

.meas tran vdout0_26ck1460 FIND v(dout0_26) AT=735.025n

.meas tran vdout0_27ck1460 FIND v(dout0_27) AT=735.025n

.meas tran vdout0_28ck1460 FIND v(dout0_28) AT=735.025n

.meas tran vdout0_29ck1460 FIND v(dout0_29) AT=735.025n

.meas tran vdout0_30ck1460 FIND v(dout0_30) AT=735.025n

.meas tran vdout0_31ck1460 FIND v(dout0_31) AT=735.025n

.meas tran vdout0_0ck1470 FIND v(dout0_0) AT=740.025n

.meas tran vdout0_1ck1470 FIND v(dout0_1) AT=740.025n

.meas tran vdout0_2ck1470 FIND v(dout0_2) AT=740.025n

.meas tran vdout0_3ck1470 FIND v(dout0_3) AT=740.025n

.meas tran vdout0_4ck1470 FIND v(dout0_4) AT=740.025n

.meas tran vdout0_5ck1470 FIND v(dout0_5) AT=740.025n

.meas tran vdout0_6ck1470 FIND v(dout0_6) AT=740.025n

.meas tran vdout0_7ck1470 FIND v(dout0_7) AT=740.025n

.meas tran vdout0_8ck1470 FIND v(dout0_8) AT=740.025n

.meas tran vdout0_9ck1470 FIND v(dout0_9) AT=740.025n

.meas tran vdout0_10ck1470 FIND v(dout0_10) AT=740.025n

.meas tran vdout0_11ck1470 FIND v(dout0_11) AT=740.025n

.meas tran vdout0_12ck1470 FIND v(dout0_12) AT=740.025n

.meas tran vdout0_13ck1470 FIND v(dout0_13) AT=740.025n

.meas tran vdout0_14ck1470 FIND v(dout0_14) AT=740.025n

.meas tran vdout0_15ck1470 FIND v(dout0_15) AT=740.025n

.meas tran vdout0_16ck1470 FIND v(dout0_16) AT=740.025n

.meas tran vdout0_17ck1470 FIND v(dout0_17) AT=740.025n

.meas tran vdout0_18ck1470 FIND v(dout0_18) AT=740.025n

.meas tran vdout0_19ck1470 FIND v(dout0_19) AT=740.025n

.meas tran vdout0_20ck1470 FIND v(dout0_20) AT=740.025n

.meas tran vdout0_21ck1470 FIND v(dout0_21) AT=740.025n

.meas tran vdout0_22ck1470 FIND v(dout0_22) AT=740.025n

.meas tran vdout0_23ck1470 FIND v(dout0_23) AT=740.025n

.meas tran vdout0_24ck1470 FIND v(dout0_24) AT=740.025n

.meas tran vdout0_25ck1470 FIND v(dout0_25) AT=740.025n

.meas tran vdout0_26ck1470 FIND v(dout0_26) AT=740.025n

.meas tran vdout0_27ck1470 FIND v(dout0_27) AT=740.025n

.meas tran vdout0_28ck1470 FIND v(dout0_28) AT=740.025n

.meas tran vdout0_29ck1470 FIND v(dout0_29) AT=740.025n

.meas tran vdout0_30ck1470 FIND v(dout0_30) AT=740.025n

.meas tran vdout0_31ck1470 FIND v(dout0_31) AT=740.025n

.meas tran vdout0_0ck1490 FIND v(dout0_0) AT=750.025n

.meas tran vdout0_1ck1490 FIND v(dout0_1) AT=750.025n

.meas tran vdout0_2ck1490 FIND v(dout0_2) AT=750.025n

.meas tran vdout0_3ck1490 FIND v(dout0_3) AT=750.025n

.meas tran vdout0_4ck1490 FIND v(dout0_4) AT=750.025n

.meas tran vdout0_5ck1490 FIND v(dout0_5) AT=750.025n

.meas tran vdout0_6ck1490 FIND v(dout0_6) AT=750.025n

.meas tran vdout0_7ck1490 FIND v(dout0_7) AT=750.025n

.meas tran vdout0_8ck1490 FIND v(dout0_8) AT=750.025n

.meas tran vdout0_9ck1490 FIND v(dout0_9) AT=750.025n

.meas tran vdout0_10ck1490 FIND v(dout0_10) AT=750.025n

.meas tran vdout0_11ck1490 FIND v(dout0_11) AT=750.025n

.meas tran vdout0_12ck1490 FIND v(dout0_12) AT=750.025n

.meas tran vdout0_13ck1490 FIND v(dout0_13) AT=750.025n

.meas tran vdout0_14ck1490 FIND v(dout0_14) AT=750.025n

.meas tran vdout0_15ck1490 FIND v(dout0_15) AT=750.025n

.meas tran vdout0_16ck1490 FIND v(dout0_16) AT=750.025n

.meas tran vdout0_17ck1490 FIND v(dout0_17) AT=750.025n

.meas tran vdout0_18ck1490 FIND v(dout0_18) AT=750.025n

.meas tran vdout0_19ck1490 FIND v(dout0_19) AT=750.025n

.meas tran vdout0_20ck1490 FIND v(dout0_20) AT=750.025n

.meas tran vdout0_21ck1490 FIND v(dout0_21) AT=750.025n

.meas tran vdout0_22ck1490 FIND v(dout0_22) AT=750.025n

.meas tran vdout0_23ck1490 FIND v(dout0_23) AT=750.025n

.meas tran vdout0_24ck1490 FIND v(dout0_24) AT=750.025n

.meas tran vdout0_25ck1490 FIND v(dout0_25) AT=750.025n

.meas tran vdout0_26ck1490 FIND v(dout0_26) AT=750.025n

.meas tran vdout0_27ck1490 FIND v(dout0_27) AT=750.025n

.meas tran vdout0_28ck1490 FIND v(dout0_28) AT=750.025n

.meas tran vdout0_29ck1490 FIND v(dout0_29) AT=750.025n

.meas tran vdout0_30ck1490 FIND v(dout0_30) AT=750.025n

.meas tran vdout0_31ck1490 FIND v(dout0_31) AT=750.025n

.meas tran vdout0_0ck1510 FIND v(dout0_0) AT=760.025n

.meas tran vdout0_1ck1510 FIND v(dout0_1) AT=760.025n

.meas tran vdout0_2ck1510 FIND v(dout0_2) AT=760.025n

.meas tran vdout0_3ck1510 FIND v(dout0_3) AT=760.025n

.meas tran vdout0_4ck1510 FIND v(dout0_4) AT=760.025n

.meas tran vdout0_5ck1510 FIND v(dout0_5) AT=760.025n

.meas tran vdout0_6ck1510 FIND v(dout0_6) AT=760.025n

.meas tran vdout0_7ck1510 FIND v(dout0_7) AT=760.025n

.meas tran vdout0_8ck1510 FIND v(dout0_8) AT=760.025n

.meas tran vdout0_9ck1510 FIND v(dout0_9) AT=760.025n

.meas tran vdout0_10ck1510 FIND v(dout0_10) AT=760.025n

.meas tran vdout0_11ck1510 FIND v(dout0_11) AT=760.025n

.meas tran vdout0_12ck1510 FIND v(dout0_12) AT=760.025n

.meas tran vdout0_13ck1510 FIND v(dout0_13) AT=760.025n

.meas tran vdout0_14ck1510 FIND v(dout0_14) AT=760.025n

.meas tran vdout0_15ck1510 FIND v(dout0_15) AT=760.025n

.meas tran vdout0_16ck1510 FIND v(dout0_16) AT=760.025n

.meas tran vdout0_17ck1510 FIND v(dout0_17) AT=760.025n

.meas tran vdout0_18ck1510 FIND v(dout0_18) AT=760.025n

.meas tran vdout0_19ck1510 FIND v(dout0_19) AT=760.025n

.meas tran vdout0_20ck1510 FIND v(dout0_20) AT=760.025n

.meas tran vdout0_21ck1510 FIND v(dout0_21) AT=760.025n

.meas tran vdout0_22ck1510 FIND v(dout0_22) AT=760.025n

.meas tran vdout0_23ck1510 FIND v(dout0_23) AT=760.025n

.meas tran vdout0_24ck1510 FIND v(dout0_24) AT=760.025n

.meas tran vdout0_25ck1510 FIND v(dout0_25) AT=760.025n

.meas tran vdout0_26ck1510 FIND v(dout0_26) AT=760.025n

.meas tran vdout0_27ck1510 FIND v(dout0_27) AT=760.025n

.meas tran vdout0_28ck1510 FIND v(dout0_28) AT=760.025n

.meas tran vdout0_29ck1510 FIND v(dout0_29) AT=760.025n

.meas tran vdout0_30ck1510 FIND v(dout0_30) AT=760.025n

.meas tran vdout0_31ck1510 FIND v(dout0_31) AT=760.025n

.meas tran vdout0_0ck1530 FIND v(dout0_0) AT=770.025n

.meas tran vdout0_1ck1530 FIND v(dout0_1) AT=770.025n

.meas tran vdout0_2ck1530 FIND v(dout0_2) AT=770.025n

.meas tran vdout0_3ck1530 FIND v(dout0_3) AT=770.025n

.meas tran vdout0_4ck1530 FIND v(dout0_4) AT=770.025n

.meas tran vdout0_5ck1530 FIND v(dout0_5) AT=770.025n

.meas tran vdout0_6ck1530 FIND v(dout0_6) AT=770.025n

.meas tran vdout0_7ck1530 FIND v(dout0_7) AT=770.025n

.meas tran vdout0_8ck1530 FIND v(dout0_8) AT=770.025n

.meas tran vdout0_9ck1530 FIND v(dout0_9) AT=770.025n

.meas tran vdout0_10ck1530 FIND v(dout0_10) AT=770.025n

.meas tran vdout0_11ck1530 FIND v(dout0_11) AT=770.025n

.meas tran vdout0_12ck1530 FIND v(dout0_12) AT=770.025n

.meas tran vdout0_13ck1530 FIND v(dout0_13) AT=770.025n

.meas tran vdout0_14ck1530 FIND v(dout0_14) AT=770.025n

.meas tran vdout0_15ck1530 FIND v(dout0_15) AT=770.025n

.meas tran vdout0_16ck1530 FIND v(dout0_16) AT=770.025n

.meas tran vdout0_17ck1530 FIND v(dout0_17) AT=770.025n

.meas tran vdout0_18ck1530 FIND v(dout0_18) AT=770.025n

.meas tran vdout0_19ck1530 FIND v(dout0_19) AT=770.025n

.meas tran vdout0_20ck1530 FIND v(dout0_20) AT=770.025n

.meas tran vdout0_21ck1530 FIND v(dout0_21) AT=770.025n

.meas tran vdout0_22ck1530 FIND v(dout0_22) AT=770.025n

.meas tran vdout0_23ck1530 FIND v(dout0_23) AT=770.025n

.meas tran vdout0_24ck1530 FIND v(dout0_24) AT=770.025n

.meas tran vdout0_25ck1530 FIND v(dout0_25) AT=770.025n

.meas tran vdout0_26ck1530 FIND v(dout0_26) AT=770.025n

.meas tran vdout0_27ck1530 FIND v(dout0_27) AT=770.025n

.meas tran vdout0_28ck1530 FIND v(dout0_28) AT=770.025n

.meas tran vdout0_29ck1530 FIND v(dout0_29) AT=770.025n

.meas tran vdout0_30ck1530 FIND v(dout0_30) AT=770.025n

.meas tran vdout0_31ck1530 FIND v(dout0_31) AT=770.025n

.meas tran vdout0_0ck1550 FIND v(dout0_0) AT=780.025n

.meas tran vdout0_1ck1550 FIND v(dout0_1) AT=780.025n

.meas tran vdout0_2ck1550 FIND v(dout0_2) AT=780.025n

.meas tran vdout0_3ck1550 FIND v(dout0_3) AT=780.025n

.meas tran vdout0_4ck1550 FIND v(dout0_4) AT=780.025n

.meas tran vdout0_5ck1550 FIND v(dout0_5) AT=780.025n

.meas tran vdout0_6ck1550 FIND v(dout0_6) AT=780.025n

.meas tran vdout0_7ck1550 FIND v(dout0_7) AT=780.025n

.meas tran vdout0_8ck1550 FIND v(dout0_8) AT=780.025n

.meas tran vdout0_9ck1550 FIND v(dout0_9) AT=780.025n

.meas tran vdout0_10ck1550 FIND v(dout0_10) AT=780.025n

.meas tran vdout0_11ck1550 FIND v(dout0_11) AT=780.025n

.meas tran vdout0_12ck1550 FIND v(dout0_12) AT=780.025n

.meas tran vdout0_13ck1550 FIND v(dout0_13) AT=780.025n

.meas tran vdout0_14ck1550 FIND v(dout0_14) AT=780.025n

.meas tran vdout0_15ck1550 FIND v(dout0_15) AT=780.025n

.meas tran vdout0_16ck1550 FIND v(dout0_16) AT=780.025n

.meas tran vdout0_17ck1550 FIND v(dout0_17) AT=780.025n

.meas tran vdout0_18ck1550 FIND v(dout0_18) AT=780.025n

.meas tran vdout0_19ck1550 FIND v(dout0_19) AT=780.025n

.meas tran vdout0_20ck1550 FIND v(dout0_20) AT=780.025n

.meas tran vdout0_21ck1550 FIND v(dout0_21) AT=780.025n

.meas tran vdout0_22ck1550 FIND v(dout0_22) AT=780.025n

.meas tran vdout0_23ck1550 FIND v(dout0_23) AT=780.025n

.meas tran vdout0_24ck1550 FIND v(dout0_24) AT=780.025n

.meas tran vdout0_25ck1550 FIND v(dout0_25) AT=780.025n

.meas tran vdout0_26ck1550 FIND v(dout0_26) AT=780.025n

.meas tran vdout0_27ck1550 FIND v(dout0_27) AT=780.025n

.meas tran vdout0_28ck1550 FIND v(dout0_28) AT=780.025n

.meas tran vdout0_29ck1550 FIND v(dout0_29) AT=780.025n

.meas tran vdout0_30ck1550 FIND v(dout0_30) AT=780.025n

.meas tran vdout0_31ck1550 FIND v(dout0_31) AT=780.025n

.meas tran vdout0_0ck1600 FIND v(dout0_0) AT=805.025n

.meas tran vdout0_1ck1600 FIND v(dout0_1) AT=805.025n

.meas tran vdout0_2ck1600 FIND v(dout0_2) AT=805.025n

.meas tran vdout0_3ck1600 FIND v(dout0_3) AT=805.025n

.meas tran vdout0_4ck1600 FIND v(dout0_4) AT=805.025n

.meas tran vdout0_5ck1600 FIND v(dout0_5) AT=805.025n

.meas tran vdout0_6ck1600 FIND v(dout0_6) AT=805.025n

.meas tran vdout0_7ck1600 FIND v(dout0_7) AT=805.025n

.meas tran vdout0_8ck1600 FIND v(dout0_8) AT=805.025n

.meas tran vdout0_9ck1600 FIND v(dout0_9) AT=805.025n

.meas tran vdout0_10ck1600 FIND v(dout0_10) AT=805.025n

.meas tran vdout0_11ck1600 FIND v(dout0_11) AT=805.025n

.meas tran vdout0_12ck1600 FIND v(dout0_12) AT=805.025n

.meas tran vdout0_13ck1600 FIND v(dout0_13) AT=805.025n

.meas tran vdout0_14ck1600 FIND v(dout0_14) AT=805.025n

.meas tran vdout0_15ck1600 FIND v(dout0_15) AT=805.025n

.meas tran vdout0_16ck1600 FIND v(dout0_16) AT=805.025n

.meas tran vdout0_17ck1600 FIND v(dout0_17) AT=805.025n

.meas tran vdout0_18ck1600 FIND v(dout0_18) AT=805.025n

.meas tran vdout0_19ck1600 FIND v(dout0_19) AT=805.025n

.meas tran vdout0_20ck1600 FIND v(dout0_20) AT=805.025n

.meas tran vdout0_21ck1600 FIND v(dout0_21) AT=805.025n

.meas tran vdout0_22ck1600 FIND v(dout0_22) AT=805.025n

.meas tran vdout0_23ck1600 FIND v(dout0_23) AT=805.025n

.meas tran vdout0_24ck1600 FIND v(dout0_24) AT=805.025n

.meas tran vdout0_25ck1600 FIND v(dout0_25) AT=805.025n

.meas tran vdout0_26ck1600 FIND v(dout0_26) AT=805.025n

.meas tran vdout0_27ck1600 FIND v(dout0_27) AT=805.025n

.meas tran vdout0_28ck1600 FIND v(dout0_28) AT=805.025n

.meas tran vdout0_29ck1600 FIND v(dout0_29) AT=805.025n

.meas tran vdout0_30ck1600 FIND v(dout0_30) AT=805.025n

.meas tran vdout0_31ck1600 FIND v(dout0_31) AT=805.025n

.meas tran vdout0_0ck1610 FIND v(dout0_0) AT=810.025n

.meas tran vdout0_1ck1610 FIND v(dout0_1) AT=810.025n

.meas tran vdout0_2ck1610 FIND v(dout0_2) AT=810.025n

.meas tran vdout0_3ck1610 FIND v(dout0_3) AT=810.025n

.meas tran vdout0_4ck1610 FIND v(dout0_4) AT=810.025n

.meas tran vdout0_5ck1610 FIND v(dout0_5) AT=810.025n

.meas tran vdout0_6ck1610 FIND v(dout0_6) AT=810.025n

.meas tran vdout0_7ck1610 FIND v(dout0_7) AT=810.025n

.meas tran vdout0_8ck1610 FIND v(dout0_8) AT=810.025n

.meas tran vdout0_9ck1610 FIND v(dout0_9) AT=810.025n

.meas tran vdout0_10ck1610 FIND v(dout0_10) AT=810.025n

.meas tran vdout0_11ck1610 FIND v(dout0_11) AT=810.025n

.meas tran vdout0_12ck1610 FIND v(dout0_12) AT=810.025n

.meas tran vdout0_13ck1610 FIND v(dout0_13) AT=810.025n

.meas tran vdout0_14ck1610 FIND v(dout0_14) AT=810.025n

.meas tran vdout0_15ck1610 FIND v(dout0_15) AT=810.025n

.meas tran vdout0_16ck1610 FIND v(dout0_16) AT=810.025n

.meas tran vdout0_17ck1610 FIND v(dout0_17) AT=810.025n

.meas tran vdout0_18ck1610 FIND v(dout0_18) AT=810.025n

.meas tran vdout0_19ck1610 FIND v(dout0_19) AT=810.025n

.meas tran vdout0_20ck1610 FIND v(dout0_20) AT=810.025n

.meas tran vdout0_21ck1610 FIND v(dout0_21) AT=810.025n

.meas tran vdout0_22ck1610 FIND v(dout0_22) AT=810.025n

.meas tran vdout0_23ck1610 FIND v(dout0_23) AT=810.025n

.meas tran vdout0_24ck1610 FIND v(dout0_24) AT=810.025n

.meas tran vdout0_25ck1610 FIND v(dout0_25) AT=810.025n

.meas tran vdout0_26ck1610 FIND v(dout0_26) AT=810.025n

.meas tran vdout0_27ck1610 FIND v(dout0_27) AT=810.025n

.meas tran vdout0_28ck1610 FIND v(dout0_28) AT=810.025n

.meas tran vdout0_29ck1610 FIND v(dout0_29) AT=810.025n

.meas tran vdout0_30ck1610 FIND v(dout0_30) AT=810.025n

.meas tran vdout0_31ck1610 FIND v(dout0_31) AT=810.025n

.meas tran vdout0_0ck1620 FIND v(dout0_0) AT=815.025n

.meas tran vdout0_1ck1620 FIND v(dout0_1) AT=815.025n

.meas tran vdout0_2ck1620 FIND v(dout0_2) AT=815.025n

.meas tran vdout0_3ck1620 FIND v(dout0_3) AT=815.025n

.meas tran vdout0_4ck1620 FIND v(dout0_4) AT=815.025n

.meas tran vdout0_5ck1620 FIND v(dout0_5) AT=815.025n

.meas tran vdout0_6ck1620 FIND v(dout0_6) AT=815.025n

.meas tran vdout0_7ck1620 FIND v(dout0_7) AT=815.025n

.meas tran vdout0_8ck1620 FIND v(dout0_8) AT=815.025n

.meas tran vdout0_9ck1620 FIND v(dout0_9) AT=815.025n

.meas tran vdout0_10ck1620 FIND v(dout0_10) AT=815.025n

.meas tran vdout0_11ck1620 FIND v(dout0_11) AT=815.025n

.meas tran vdout0_12ck1620 FIND v(dout0_12) AT=815.025n

.meas tran vdout0_13ck1620 FIND v(dout0_13) AT=815.025n

.meas tran vdout0_14ck1620 FIND v(dout0_14) AT=815.025n

.meas tran vdout0_15ck1620 FIND v(dout0_15) AT=815.025n

.meas tran vdout0_16ck1620 FIND v(dout0_16) AT=815.025n

.meas tran vdout0_17ck1620 FIND v(dout0_17) AT=815.025n

.meas tran vdout0_18ck1620 FIND v(dout0_18) AT=815.025n

.meas tran vdout0_19ck1620 FIND v(dout0_19) AT=815.025n

.meas tran vdout0_20ck1620 FIND v(dout0_20) AT=815.025n

.meas tran vdout0_21ck1620 FIND v(dout0_21) AT=815.025n

.meas tran vdout0_22ck1620 FIND v(dout0_22) AT=815.025n

.meas tran vdout0_23ck1620 FIND v(dout0_23) AT=815.025n

.meas tran vdout0_24ck1620 FIND v(dout0_24) AT=815.025n

.meas tran vdout0_25ck1620 FIND v(dout0_25) AT=815.025n

.meas tran vdout0_26ck1620 FIND v(dout0_26) AT=815.025n

.meas tran vdout0_27ck1620 FIND v(dout0_27) AT=815.025n

.meas tran vdout0_28ck1620 FIND v(dout0_28) AT=815.025n

.meas tran vdout0_29ck1620 FIND v(dout0_29) AT=815.025n

.meas tran vdout0_30ck1620 FIND v(dout0_30) AT=815.025n

.meas tran vdout0_31ck1620 FIND v(dout0_31) AT=815.025n

.meas tran vdout0_0ck1640 FIND v(dout0_0) AT=825.025n

.meas tran vdout0_1ck1640 FIND v(dout0_1) AT=825.025n

.meas tran vdout0_2ck1640 FIND v(dout0_2) AT=825.025n

.meas tran vdout0_3ck1640 FIND v(dout0_3) AT=825.025n

.meas tran vdout0_4ck1640 FIND v(dout0_4) AT=825.025n

.meas tran vdout0_5ck1640 FIND v(dout0_5) AT=825.025n

.meas tran vdout0_6ck1640 FIND v(dout0_6) AT=825.025n

.meas tran vdout0_7ck1640 FIND v(dout0_7) AT=825.025n

.meas tran vdout0_8ck1640 FIND v(dout0_8) AT=825.025n

.meas tran vdout0_9ck1640 FIND v(dout0_9) AT=825.025n

.meas tran vdout0_10ck1640 FIND v(dout0_10) AT=825.025n

.meas tran vdout0_11ck1640 FIND v(dout0_11) AT=825.025n

.meas tran vdout0_12ck1640 FIND v(dout0_12) AT=825.025n

.meas tran vdout0_13ck1640 FIND v(dout0_13) AT=825.025n

.meas tran vdout0_14ck1640 FIND v(dout0_14) AT=825.025n

.meas tran vdout0_15ck1640 FIND v(dout0_15) AT=825.025n

.meas tran vdout0_16ck1640 FIND v(dout0_16) AT=825.025n

.meas tran vdout0_17ck1640 FIND v(dout0_17) AT=825.025n

.meas tran vdout0_18ck1640 FIND v(dout0_18) AT=825.025n

.meas tran vdout0_19ck1640 FIND v(dout0_19) AT=825.025n

.meas tran vdout0_20ck1640 FIND v(dout0_20) AT=825.025n

.meas tran vdout0_21ck1640 FIND v(dout0_21) AT=825.025n

.meas tran vdout0_22ck1640 FIND v(dout0_22) AT=825.025n

.meas tran vdout0_23ck1640 FIND v(dout0_23) AT=825.025n

.meas tran vdout0_24ck1640 FIND v(dout0_24) AT=825.025n

.meas tran vdout0_25ck1640 FIND v(dout0_25) AT=825.025n

.meas tran vdout0_26ck1640 FIND v(dout0_26) AT=825.025n

.meas tran vdout0_27ck1640 FIND v(dout0_27) AT=825.025n

.meas tran vdout0_28ck1640 FIND v(dout0_28) AT=825.025n

.meas tran vdout0_29ck1640 FIND v(dout0_29) AT=825.025n

.meas tran vdout0_30ck1640 FIND v(dout0_30) AT=825.025n

.meas tran vdout0_31ck1640 FIND v(dout0_31) AT=825.025n

.meas tran vdout0_0ck1650 FIND v(dout0_0) AT=830.025n

.meas tran vdout0_1ck1650 FIND v(dout0_1) AT=830.025n

.meas tran vdout0_2ck1650 FIND v(dout0_2) AT=830.025n

.meas tran vdout0_3ck1650 FIND v(dout0_3) AT=830.025n

.meas tran vdout0_4ck1650 FIND v(dout0_4) AT=830.025n

.meas tran vdout0_5ck1650 FIND v(dout0_5) AT=830.025n

.meas tran vdout0_6ck1650 FIND v(dout0_6) AT=830.025n

.meas tran vdout0_7ck1650 FIND v(dout0_7) AT=830.025n

.meas tran vdout0_8ck1650 FIND v(dout0_8) AT=830.025n

.meas tran vdout0_9ck1650 FIND v(dout0_9) AT=830.025n

.meas tran vdout0_10ck1650 FIND v(dout0_10) AT=830.025n

.meas tran vdout0_11ck1650 FIND v(dout0_11) AT=830.025n

.meas tran vdout0_12ck1650 FIND v(dout0_12) AT=830.025n

.meas tran vdout0_13ck1650 FIND v(dout0_13) AT=830.025n

.meas tran vdout0_14ck1650 FIND v(dout0_14) AT=830.025n

.meas tran vdout0_15ck1650 FIND v(dout0_15) AT=830.025n

.meas tran vdout0_16ck1650 FIND v(dout0_16) AT=830.025n

.meas tran vdout0_17ck1650 FIND v(dout0_17) AT=830.025n

.meas tran vdout0_18ck1650 FIND v(dout0_18) AT=830.025n

.meas tran vdout0_19ck1650 FIND v(dout0_19) AT=830.025n

.meas tran vdout0_20ck1650 FIND v(dout0_20) AT=830.025n

.meas tran vdout0_21ck1650 FIND v(dout0_21) AT=830.025n

.meas tran vdout0_22ck1650 FIND v(dout0_22) AT=830.025n

.meas tran vdout0_23ck1650 FIND v(dout0_23) AT=830.025n

.meas tran vdout0_24ck1650 FIND v(dout0_24) AT=830.025n

.meas tran vdout0_25ck1650 FIND v(dout0_25) AT=830.025n

.meas tran vdout0_26ck1650 FIND v(dout0_26) AT=830.025n

.meas tran vdout0_27ck1650 FIND v(dout0_27) AT=830.025n

.meas tran vdout0_28ck1650 FIND v(dout0_28) AT=830.025n

.meas tran vdout0_29ck1650 FIND v(dout0_29) AT=830.025n

.meas tran vdout0_30ck1650 FIND v(dout0_30) AT=830.025n

.meas tran vdout0_31ck1650 FIND v(dout0_31) AT=830.025n

.meas tran vdout0_0ck1660 FIND v(dout0_0) AT=835.025n

.meas tran vdout0_1ck1660 FIND v(dout0_1) AT=835.025n

.meas tran vdout0_2ck1660 FIND v(dout0_2) AT=835.025n

.meas tran vdout0_3ck1660 FIND v(dout0_3) AT=835.025n

.meas tran vdout0_4ck1660 FIND v(dout0_4) AT=835.025n

.meas tran vdout0_5ck1660 FIND v(dout0_5) AT=835.025n

.meas tran vdout0_6ck1660 FIND v(dout0_6) AT=835.025n

.meas tran vdout0_7ck1660 FIND v(dout0_7) AT=835.025n

.meas tran vdout0_8ck1660 FIND v(dout0_8) AT=835.025n

.meas tran vdout0_9ck1660 FIND v(dout0_9) AT=835.025n

.meas tran vdout0_10ck1660 FIND v(dout0_10) AT=835.025n

.meas tran vdout0_11ck1660 FIND v(dout0_11) AT=835.025n

.meas tran vdout0_12ck1660 FIND v(dout0_12) AT=835.025n

.meas tran vdout0_13ck1660 FIND v(dout0_13) AT=835.025n

.meas tran vdout0_14ck1660 FIND v(dout0_14) AT=835.025n

.meas tran vdout0_15ck1660 FIND v(dout0_15) AT=835.025n

.meas tran vdout0_16ck1660 FIND v(dout0_16) AT=835.025n

.meas tran vdout0_17ck1660 FIND v(dout0_17) AT=835.025n

.meas tran vdout0_18ck1660 FIND v(dout0_18) AT=835.025n

.meas tran vdout0_19ck1660 FIND v(dout0_19) AT=835.025n

.meas tran vdout0_20ck1660 FIND v(dout0_20) AT=835.025n

.meas tran vdout0_21ck1660 FIND v(dout0_21) AT=835.025n

.meas tran vdout0_22ck1660 FIND v(dout0_22) AT=835.025n

.meas tran vdout0_23ck1660 FIND v(dout0_23) AT=835.025n

.meas tran vdout0_24ck1660 FIND v(dout0_24) AT=835.025n

.meas tran vdout0_25ck1660 FIND v(dout0_25) AT=835.025n

.meas tran vdout0_26ck1660 FIND v(dout0_26) AT=835.025n

.meas tran vdout0_27ck1660 FIND v(dout0_27) AT=835.025n

.meas tran vdout0_28ck1660 FIND v(dout0_28) AT=835.025n

.meas tran vdout0_29ck1660 FIND v(dout0_29) AT=835.025n

.meas tran vdout0_30ck1660 FIND v(dout0_30) AT=835.025n

.meas tran vdout0_31ck1660 FIND v(dout0_31) AT=835.025n

.meas tran vdout0_0ck1670 FIND v(dout0_0) AT=840.025n

.meas tran vdout0_1ck1670 FIND v(dout0_1) AT=840.025n

.meas tran vdout0_2ck1670 FIND v(dout0_2) AT=840.025n

.meas tran vdout0_3ck1670 FIND v(dout0_3) AT=840.025n

.meas tran vdout0_4ck1670 FIND v(dout0_4) AT=840.025n

.meas tran vdout0_5ck1670 FIND v(dout0_5) AT=840.025n

.meas tran vdout0_6ck1670 FIND v(dout0_6) AT=840.025n

.meas tran vdout0_7ck1670 FIND v(dout0_7) AT=840.025n

.meas tran vdout0_8ck1670 FIND v(dout0_8) AT=840.025n

.meas tran vdout0_9ck1670 FIND v(dout0_9) AT=840.025n

.meas tran vdout0_10ck1670 FIND v(dout0_10) AT=840.025n

.meas tran vdout0_11ck1670 FIND v(dout0_11) AT=840.025n

.meas tran vdout0_12ck1670 FIND v(dout0_12) AT=840.025n

.meas tran vdout0_13ck1670 FIND v(dout0_13) AT=840.025n

.meas tran vdout0_14ck1670 FIND v(dout0_14) AT=840.025n

.meas tran vdout0_15ck1670 FIND v(dout0_15) AT=840.025n

.meas tran vdout0_16ck1670 FIND v(dout0_16) AT=840.025n

.meas tran vdout0_17ck1670 FIND v(dout0_17) AT=840.025n

.meas tran vdout0_18ck1670 FIND v(dout0_18) AT=840.025n

.meas tran vdout0_19ck1670 FIND v(dout0_19) AT=840.025n

.meas tran vdout0_20ck1670 FIND v(dout0_20) AT=840.025n

.meas tran vdout0_21ck1670 FIND v(dout0_21) AT=840.025n

.meas tran vdout0_22ck1670 FIND v(dout0_22) AT=840.025n

.meas tran vdout0_23ck1670 FIND v(dout0_23) AT=840.025n

.meas tran vdout0_24ck1670 FIND v(dout0_24) AT=840.025n

.meas tran vdout0_25ck1670 FIND v(dout0_25) AT=840.025n

.meas tran vdout0_26ck1670 FIND v(dout0_26) AT=840.025n

.meas tran vdout0_27ck1670 FIND v(dout0_27) AT=840.025n

.meas tran vdout0_28ck1670 FIND v(dout0_28) AT=840.025n

.meas tran vdout0_29ck1670 FIND v(dout0_29) AT=840.025n

.meas tran vdout0_30ck1670 FIND v(dout0_30) AT=840.025n

.meas tran vdout0_31ck1670 FIND v(dout0_31) AT=840.025n

.meas tran vdout0_0ck1700 FIND v(dout0_0) AT=855.025n

.meas tran vdout0_1ck1700 FIND v(dout0_1) AT=855.025n

.meas tran vdout0_2ck1700 FIND v(dout0_2) AT=855.025n

.meas tran vdout0_3ck1700 FIND v(dout0_3) AT=855.025n

.meas tran vdout0_4ck1700 FIND v(dout0_4) AT=855.025n

.meas tran vdout0_5ck1700 FIND v(dout0_5) AT=855.025n

.meas tran vdout0_6ck1700 FIND v(dout0_6) AT=855.025n

.meas tran vdout0_7ck1700 FIND v(dout0_7) AT=855.025n

.meas tran vdout0_8ck1700 FIND v(dout0_8) AT=855.025n

.meas tran vdout0_9ck1700 FIND v(dout0_9) AT=855.025n

.meas tran vdout0_10ck1700 FIND v(dout0_10) AT=855.025n

.meas tran vdout0_11ck1700 FIND v(dout0_11) AT=855.025n

.meas tran vdout0_12ck1700 FIND v(dout0_12) AT=855.025n

.meas tran vdout0_13ck1700 FIND v(dout0_13) AT=855.025n

.meas tran vdout0_14ck1700 FIND v(dout0_14) AT=855.025n

.meas tran vdout0_15ck1700 FIND v(dout0_15) AT=855.025n

.meas tran vdout0_16ck1700 FIND v(dout0_16) AT=855.025n

.meas tran vdout0_17ck1700 FIND v(dout0_17) AT=855.025n

.meas tran vdout0_18ck1700 FIND v(dout0_18) AT=855.025n

.meas tran vdout0_19ck1700 FIND v(dout0_19) AT=855.025n

.meas tran vdout0_20ck1700 FIND v(dout0_20) AT=855.025n

.meas tran vdout0_21ck1700 FIND v(dout0_21) AT=855.025n

.meas tran vdout0_22ck1700 FIND v(dout0_22) AT=855.025n

.meas tran vdout0_23ck1700 FIND v(dout0_23) AT=855.025n

.meas tran vdout0_24ck1700 FIND v(dout0_24) AT=855.025n

.meas tran vdout0_25ck1700 FIND v(dout0_25) AT=855.025n

.meas tran vdout0_26ck1700 FIND v(dout0_26) AT=855.025n

.meas tran vdout0_27ck1700 FIND v(dout0_27) AT=855.025n

.meas tran vdout0_28ck1700 FIND v(dout0_28) AT=855.025n

.meas tran vdout0_29ck1700 FIND v(dout0_29) AT=855.025n

.meas tran vdout0_30ck1700 FIND v(dout0_30) AT=855.025n

.meas tran vdout0_31ck1700 FIND v(dout0_31) AT=855.025n

.meas tran vdout0_0ck1710 FIND v(dout0_0) AT=860.025n

.meas tran vdout0_1ck1710 FIND v(dout0_1) AT=860.025n

.meas tran vdout0_2ck1710 FIND v(dout0_2) AT=860.025n

.meas tran vdout0_3ck1710 FIND v(dout0_3) AT=860.025n

.meas tran vdout0_4ck1710 FIND v(dout0_4) AT=860.025n

.meas tran vdout0_5ck1710 FIND v(dout0_5) AT=860.025n

.meas tran vdout0_6ck1710 FIND v(dout0_6) AT=860.025n

.meas tran vdout0_7ck1710 FIND v(dout0_7) AT=860.025n

.meas tran vdout0_8ck1710 FIND v(dout0_8) AT=860.025n

.meas tran vdout0_9ck1710 FIND v(dout0_9) AT=860.025n

.meas tran vdout0_10ck1710 FIND v(dout0_10) AT=860.025n

.meas tran vdout0_11ck1710 FIND v(dout0_11) AT=860.025n

.meas tran vdout0_12ck1710 FIND v(dout0_12) AT=860.025n

.meas tran vdout0_13ck1710 FIND v(dout0_13) AT=860.025n

.meas tran vdout0_14ck1710 FIND v(dout0_14) AT=860.025n

.meas tran vdout0_15ck1710 FIND v(dout0_15) AT=860.025n

.meas tran vdout0_16ck1710 FIND v(dout0_16) AT=860.025n

.meas tran vdout0_17ck1710 FIND v(dout0_17) AT=860.025n

.meas tran vdout0_18ck1710 FIND v(dout0_18) AT=860.025n

.meas tran vdout0_19ck1710 FIND v(dout0_19) AT=860.025n

.meas tran vdout0_20ck1710 FIND v(dout0_20) AT=860.025n

.meas tran vdout0_21ck1710 FIND v(dout0_21) AT=860.025n

.meas tran vdout0_22ck1710 FIND v(dout0_22) AT=860.025n

.meas tran vdout0_23ck1710 FIND v(dout0_23) AT=860.025n

.meas tran vdout0_24ck1710 FIND v(dout0_24) AT=860.025n

.meas tran vdout0_25ck1710 FIND v(dout0_25) AT=860.025n

.meas tran vdout0_26ck1710 FIND v(dout0_26) AT=860.025n

.meas tran vdout0_27ck1710 FIND v(dout0_27) AT=860.025n

.meas tran vdout0_28ck1710 FIND v(dout0_28) AT=860.025n

.meas tran vdout0_29ck1710 FIND v(dout0_29) AT=860.025n

.meas tran vdout0_30ck1710 FIND v(dout0_30) AT=860.025n

.meas tran vdout0_31ck1710 FIND v(dout0_31) AT=860.025n

.meas tran vdout0_0ck1770 FIND v(dout0_0) AT=890.025n

.meas tran vdout0_1ck1770 FIND v(dout0_1) AT=890.025n

.meas tran vdout0_2ck1770 FIND v(dout0_2) AT=890.025n

.meas tran vdout0_3ck1770 FIND v(dout0_3) AT=890.025n

.meas tran vdout0_4ck1770 FIND v(dout0_4) AT=890.025n

.meas tran vdout0_5ck1770 FIND v(dout0_5) AT=890.025n

.meas tran vdout0_6ck1770 FIND v(dout0_6) AT=890.025n

.meas tran vdout0_7ck1770 FIND v(dout0_7) AT=890.025n

.meas tran vdout0_8ck1770 FIND v(dout0_8) AT=890.025n

.meas tran vdout0_9ck1770 FIND v(dout0_9) AT=890.025n

.meas tran vdout0_10ck1770 FIND v(dout0_10) AT=890.025n

.meas tran vdout0_11ck1770 FIND v(dout0_11) AT=890.025n

.meas tran vdout0_12ck1770 FIND v(dout0_12) AT=890.025n

.meas tran vdout0_13ck1770 FIND v(dout0_13) AT=890.025n

.meas tran vdout0_14ck1770 FIND v(dout0_14) AT=890.025n

.meas tran vdout0_15ck1770 FIND v(dout0_15) AT=890.025n

.meas tran vdout0_16ck1770 FIND v(dout0_16) AT=890.025n

.meas tran vdout0_17ck1770 FIND v(dout0_17) AT=890.025n

.meas tran vdout0_18ck1770 FIND v(dout0_18) AT=890.025n

.meas tran vdout0_19ck1770 FIND v(dout0_19) AT=890.025n

.meas tran vdout0_20ck1770 FIND v(dout0_20) AT=890.025n

.meas tran vdout0_21ck1770 FIND v(dout0_21) AT=890.025n

.meas tran vdout0_22ck1770 FIND v(dout0_22) AT=890.025n

.meas tran vdout0_23ck1770 FIND v(dout0_23) AT=890.025n

.meas tran vdout0_24ck1770 FIND v(dout0_24) AT=890.025n

.meas tran vdout0_25ck1770 FIND v(dout0_25) AT=890.025n

.meas tran vdout0_26ck1770 FIND v(dout0_26) AT=890.025n

.meas tran vdout0_27ck1770 FIND v(dout0_27) AT=890.025n

.meas tran vdout0_28ck1770 FIND v(dout0_28) AT=890.025n

.meas tran vdout0_29ck1770 FIND v(dout0_29) AT=890.025n

.meas tran vdout0_30ck1770 FIND v(dout0_30) AT=890.025n

.meas tran vdout0_31ck1770 FIND v(dout0_31) AT=890.025n

.meas tran vdout0_0ck1790 FIND v(dout0_0) AT=900.025n

.meas tran vdout0_1ck1790 FIND v(dout0_1) AT=900.025n

.meas tran vdout0_2ck1790 FIND v(dout0_2) AT=900.025n

.meas tran vdout0_3ck1790 FIND v(dout0_3) AT=900.025n

.meas tran vdout0_4ck1790 FIND v(dout0_4) AT=900.025n

.meas tran vdout0_5ck1790 FIND v(dout0_5) AT=900.025n

.meas tran vdout0_6ck1790 FIND v(dout0_6) AT=900.025n

.meas tran vdout0_7ck1790 FIND v(dout0_7) AT=900.025n

.meas tran vdout0_8ck1790 FIND v(dout0_8) AT=900.025n

.meas tran vdout0_9ck1790 FIND v(dout0_9) AT=900.025n

.meas tran vdout0_10ck1790 FIND v(dout0_10) AT=900.025n

.meas tran vdout0_11ck1790 FIND v(dout0_11) AT=900.025n

.meas tran vdout0_12ck1790 FIND v(dout0_12) AT=900.025n

.meas tran vdout0_13ck1790 FIND v(dout0_13) AT=900.025n

.meas tran vdout0_14ck1790 FIND v(dout0_14) AT=900.025n

.meas tran vdout0_15ck1790 FIND v(dout0_15) AT=900.025n

.meas tran vdout0_16ck1790 FIND v(dout0_16) AT=900.025n

.meas tran vdout0_17ck1790 FIND v(dout0_17) AT=900.025n

.meas tran vdout0_18ck1790 FIND v(dout0_18) AT=900.025n

.meas tran vdout0_19ck1790 FIND v(dout0_19) AT=900.025n

.meas tran vdout0_20ck1790 FIND v(dout0_20) AT=900.025n

.meas tran vdout0_21ck1790 FIND v(dout0_21) AT=900.025n

.meas tran vdout0_22ck1790 FIND v(dout0_22) AT=900.025n

.meas tran vdout0_23ck1790 FIND v(dout0_23) AT=900.025n

.meas tran vdout0_24ck1790 FIND v(dout0_24) AT=900.025n

.meas tran vdout0_25ck1790 FIND v(dout0_25) AT=900.025n

.meas tran vdout0_26ck1790 FIND v(dout0_26) AT=900.025n

.meas tran vdout0_27ck1790 FIND v(dout0_27) AT=900.025n

.meas tran vdout0_28ck1790 FIND v(dout0_28) AT=900.025n

.meas tran vdout0_29ck1790 FIND v(dout0_29) AT=900.025n

.meas tran vdout0_30ck1790 FIND v(dout0_30) AT=900.025n

.meas tran vdout0_31ck1790 FIND v(dout0_31) AT=900.025n

.meas tran vdout0_0ck1840 FIND v(dout0_0) AT=925.025n

.meas tran vdout0_1ck1840 FIND v(dout0_1) AT=925.025n

.meas tran vdout0_2ck1840 FIND v(dout0_2) AT=925.025n

.meas tran vdout0_3ck1840 FIND v(dout0_3) AT=925.025n

.meas tran vdout0_4ck1840 FIND v(dout0_4) AT=925.025n

.meas tran vdout0_5ck1840 FIND v(dout0_5) AT=925.025n

.meas tran vdout0_6ck1840 FIND v(dout0_6) AT=925.025n

.meas tran vdout0_7ck1840 FIND v(dout0_7) AT=925.025n

.meas tran vdout0_8ck1840 FIND v(dout0_8) AT=925.025n

.meas tran vdout0_9ck1840 FIND v(dout0_9) AT=925.025n

.meas tran vdout0_10ck1840 FIND v(dout0_10) AT=925.025n

.meas tran vdout0_11ck1840 FIND v(dout0_11) AT=925.025n

.meas tran vdout0_12ck1840 FIND v(dout0_12) AT=925.025n

.meas tran vdout0_13ck1840 FIND v(dout0_13) AT=925.025n

.meas tran vdout0_14ck1840 FIND v(dout0_14) AT=925.025n

.meas tran vdout0_15ck1840 FIND v(dout0_15) AT=925.025n

.meas tran vdout0_16ck1840 FIND v(dout0_16) AT=925.025n

.meas tran vdout0_17ck1840 FIND v(dout0_17) AT=925.025n

.meas tran vdout0_18ck1840 FIND v(dout0_18) AT=925.025n

.meas tran vdout0_19ck1840 FIND v(dout0_19) AT=925.025n

.meas tran vdout0_20ck1840 FIND v(dout0_20) AT=925.025n

.meas tran vdout0_21ck1840 FIND v(dout0_21) AT=925.025n

.meas tran vdout0_22ck1840 FIND v(dout0_22) AT=925.025n

.meas tran vdout0_23ck1840 FIND v(dout0_23) AT=925.025n

.meas tran vdout0_24ck1840 FIND v(dout0_24) AT=925.025n

.meas tran vdout0_25ck1840 FIND v(dout0_25) AT=925.025n

.meas tran vdout0_26ck1840 FIND v(dout0_26) AT=925.025n

.meas tran vdout0_27ck1840 FIND v(dout0_27) AT=925.025n

.meas tran vdout0_28ck1840 FIND v(dout0_28) AT=925.025n

.meas tran vdout0_29ck1840 FIND v(dout0_29) AT=925.025n

.meas tran vdout0_30ck1840 FIND v(dout0_30) AT=925.025n

.meas tran vdout0_31ck1840 FIND v(dout0_31) AT=925.025n

.meas tran vdout0_0ck1860 FIND v(dout0_0) AT=935.025n

.meas tran vdout0_1ck1860 FIND v(dout0_1) AT=935.025n

.meas tran vdout0_2ck1860 FIND v(dout0_2) AT=935.025n

.meas tran vdout0_3ck1860 FIND v(dout0_3) AT=935.025n

.meas tran vdout0_4ck1860 FIND v(dout0_4) AT=935.025n

.meas tran vdout0_5ck1860 FIND v(dout0_5) AT=935.025n

.meas tran vdout0_6ck1860 FIND v(dout0_6) AT=935.025n

.meas tran vdout0_7ck1860 FIND v(dout0_7) AT=935.025n

.meas tran vdout0_8ck1860 FIND v(dout0_8) AT=935.025n

.meas tran vdout0_9ck1860 FIND v(dout0_9) AT=935.025n

.meas tran vdout0_10ck1860 FIND v(dout0_10) AT=935.025n

.meas tran vdout0_11ck1860 FIND v(dout0_11) AT=935.025n

.meas tran vdout0_12ck1860 FIND v(dout0_12) AT=935.025n

.meas tran vdout0_13ck1860 FIND v(dout0_13) AT=935.025n

.meas tran vdout0_14ck1860 FIND v(dout0_14) AT=935.025n

.meas tran vdout0_15ck1860 FIND v(dout0_15) AT=935.025n

.meas tran vdout0_16ck1860 FIND v(dout0_16) AT=935.025n

.meas tran vdout0_17ck1860 FIND v(dout0_17) AT=935.025n

.meas tran vdout0_18ck1860 FIND v(dout0_18) AT=935.025n

.meas tran vdout0_19ck1860 FIND v(dout0_19) AT=935.025n

.meas tran vdout0_20ck1860 FIND v(dout0_20) AT=935.025n

.meas tran vdout0_21ck1860 FIND v(dout0_21) AT=935.025n

.meas tran vdout0_22ck1860 FIND v(dout0_22) AT=935.025n

.meas tran vdout0_23ck1860 FIND v(dout0_23) AT=935.025n

.meas tran vdout0_24ck1860 FIND v(dout0_24) AT=935.025n

.meas tran vdout0_25ck1860 FIND v(dout0_25) AT=935.025n

.meas tran vdout0_26ck1860 FIND v(dout0_26) AT=935.025n

.meas tran vdout0_27ck1860 FIND v(dout0_27) AT=935.025n

.meas tran vdout0_28ck1860 FIND v(dout0_28) AT=935.025n

.meas tran vdout0_29ck1860 FIND v(dout0_29) AT=935.025n

.meas tran vdout0_30ck1860 FIND v(dout0_30) AT=935.025n

.meas tran vdout0_31ck1860 FIND v(dout0_31) AT=935.025n

.meas tran vdout0_0ck1870 FIND v(dout0_0) AT=940.025n

.meas tran vdout0_1ck1870 FIND v(dout0_1) AT=940.025n

.meas tran vdout0_2ck1870 FIND v(dout0_2) AT=940.025n

.meas tran vdout0_3ck1870 FIND v(dout0_3) AT=940.025n

.meas tran vdout0_4ck1870 FIND v(dout0_4) AT=940.025n

.meas tran vdout0_5ck1870 FIND v(dout0_5) AT=940.025n

.meas tran vdout0_6ck1870 FIND v(dout0_6) AT=940.025n

.meas tran vdout0_7ck1870 FIND v(dout0_7) AT=940.025n

.meas tran vdout0_8ck1870 FIND v(dout0_8) AT=940.025n

.meas tran vdout0_9ck1870 FIND v(dout0_9) AT=940.025n

.meas tran vdout0_10ck1870 FIND v(dout0_10) AT=940.025n

.meas tran vdout0_11ck1870 FIND v(dout0_11) AT=940.025n

.meas tran vdout0_12ck1870 FIND v(dout0_12) AT=940.025n

.meas tran vdout0_13ck1870 FIND v(dout0_13) AT=940.025n

.meas tran vdout0_14ck1870 FIND v(dout0_14) AT=940.025n

.meas tran vdout0_15ck1870 FIND v(dout0_15) AT=940.025n

.meas tran vdout0_16ck1870 FIND v(dout0_16) AT=940.025n

.meas tran vdout0_17ck1870 FIND v(dout0_17) AT=940.025n

.meas tran vdout0_18ck1870 FIND v(dout0_18) AT=940.025n

.meas tran vdout0_19ck1870 FIND v(dout0_19) AT=940.025n

.meas tran vdout0_20ck1870 FIND v(dout0_20) AT=940.025n

.meas tran vdout0_21ck1870 FIND v(dout0_21) AT=940.025n

.meas tran vdout0_22ck1870 FIND v(dout0_22) AT=940.025n

.meas tran vdout0_23ck1870 FIND v(dout0_23) AT=940.025n

.meas tran vdout0_24ck1870 FIND v(dout0_24) AT=940.025n

.meas tran vdout0_25ck1870 FIND v(dout0_25) AT=940.025n

.meas tran vdout0_26ck1870 FIND v(dout0_26) AT=940.025n

.meas tran vdout0_27ck1870 FIND v(dout0_27) AT=940.025n

.meas tran vdout0_28ck1870 FIND v(dout0_28) AT=940.025n

.meas tran vdout0_29ck1870 FIND v(dout0_29) AT=940.025n

.meas tran vdout0_30ck1870 FIND v(dout0_30) AT=940.025n

.meas tran vdout0_31ck1870 FIND v(dout0_31) AT=940.025n

.meas tran vdout0_0ck1880 FIND v(dout0_0) AT=945.025n

.meas tran vdout0_1ck1880 FIND v(dout0_1) AT=945.025n

.meas tran vdout0_2ck1880 FIND v(dout0_2) AT=945.025n

.meas tran vdout0_3ck1880 FIND v(dout0_3) AT=945.025n

.meas tran vdout0_4ck1880 FIND v(dout0_4) AT=945.025n

.meas tran vdout0_5ck1880 FIND v(dout0_5) AT=945.025n

.meas tran vdout0_6ck1880 FIND v(dout0_6) AT=945.025n

.meas tran vdout0_7ck1880 FIND v(dout0_7) AT=945.025n

.meas tran vdout0_8ck1880 FIND v(dout0_8) AT=945.025n

.meas tran vdout0_9ck1880 FIND v(dout0_9) AT=945.025n

.meas tran vdout0_10ck1880 FIND v(dout0_10) AT=945.025n

.meas tran vdout0_11ck1880 FIND v(dout0_11) AT=945.025n

.meas tran vdout0_12ck1880 FIND v(dout0_12) AT=945.025n

.meas tran vdout0_13ck1880 FIND v(dout0_13) AT=945.025n

.meas tran vdout0_14ck1880 FIND v(dout0_14) AT=945.025n

.meas tran vdout0_15ck1880 FIND v(dout0_15) AT=945.025n

.meas tran vdout0_16ck1880 FIND v(dout0_16) AT=945.025n

.meas tran vdout0_17ck1880 FIND v(dout0_17) AT=945.025n

.meas tran vdout0_18ck1880 FIND v(dout0_18) AT=945.025n

.meas tran vdout0_19ck1880 FIND v(dout0_19) AT=945.025n

.meas tran vdout0_20ck1880 FIND v(dout0_20) AT=945.025n

.meas tran vdout0_21ck1880 FIND v(dout0_21) AT=945.025n

.meas tran vdout0_22ck1880 FIND v(dout0_22) AT=945.025n

.meas tran vdout0_23ck1880 FIND v(dout0_23) AT=945.025n

.meas tran vdout0_24ck1880 FIND v(dout0_24) AT=945.025n

.meas tran vdout0_25ck1880 FIND v(dout0_25) AT=945.025n

.meas tran vdout0_26ck1880 FIND v(dout0_26) AT=945.025n

.meas tran vdout0_27ck1880 FIND v(dout0_27) AT=945.025n

.meas tran vdout0_28ck1880 FIND v(dout0_28) AT=945.025n

.meas tran vdout0_29ck1880 FIND v(dout0_29) AT=945.025n

.meas tran vdout0_30ck1880 FIND v(dout0_30) AT=945.025n

.meas tran vdout0_31ck1880 FIND v(dout0_31) AT=945.025n

.meas tran vdout0_0ck1920 FIND v(dout0_0) AT=965.025n

.meas tran vdout0_1ck1920 FIND v(dout0_1) AT=965.025n

.meas tran vdout0_2ck1920 FIND v(dout0_2) AT=965.025n

.meas tran vdout0_3ck1920 FIND v(dout0_3) AT=965.025n

.meas tran vdout0_4ck1920 FIND v(dout0_4) AT=965.025n

.meas tran vdout0_5ck1920 FIND v(dout0_5) AT=965.025n

.meas tran vdout0_6ck1920 FIND v(dout0_6) AT=965.025n

.meas tran vdout0_7ck1920 FIND v(dout0_7) AT=965.025n

.meas tran vdout0_8ck1920 FIND v(dout0_8) AT=965.025n

.meas tran vdout0_9ck1920 FIND v(dout0_9) AT=965.025n

.meas tran vdout0_10ck1920 FIND v(dout0_10) AT=965.025n

.meas tran vdout0_11ck1920 FIND v(dout0_11) AT=965.025n

.meas tran vdout0_12ck1920 FIND v(dout0_12) AT=965.025n

.meas tran vdout0_13ck1920 FIND v(dout0_13) AT=965.025n

.meas tran vdout0_14ck1920 FIND v(dout0_14) AT=965.025n

.meas tran vdout0_15ck1920 FIND v(dout0_15) AT=965.025n

.meas tran vdout0_16ck1920 FIND v(dout0_16) AT=965.025n

.meas tran vdout0_17ck1920 FIND v(dout0_17) AT=965.025n

.meas tran vdout0_18ck1920 FIND v(dout0_18) AT=965.025n

.meas tran vdout0_19ck1920 FIND v(dout0_19) AT=965.025n

.meas tran vdout0_20ck1920 FIND v(dout0_20) AT=965.025n

.meas tran vdout0_21ck1920 FIND v(dout0_21) AT=965.025n

.meas tran vdout0_22ck1920 FIND v(dout0_22) AT=965.025n

.meas tran vdout0_23ck1920 FIND v(dout0_23) AT=965.025n

.meas tran vdout0_24ck1920 FIND v(dout0_24) AT=965.025n

.meas tran vdout0_25ck1920 FIND v(dout0_25) AT=965.025n

.meas tran vdout0_26ck1920 FIND v(dout0_26) AT=965.025n

.meas tran vdout0_27ck1920 FIND v(dout0_27) AT=965.025n

.meas tran vdout0_28ck1920 FIND v(dout0_28) AT=965.025n

.meas tran vdout0_29ck1920 FIND v(dout0_29) AT=965.025n

.meas tran vdout0_30ck1920 FIND v(dout0_30) AT=965.025n

.meas tran vdout0_31ck1920 FIND v(dout0_31) AT=965.025n

.meas tran vdout0_0ck1930 FIND v(dout0_0) AT=970.025n

.meas tran vdout0_1ck1930 FIND v(dout0_1) AT=970.025n

.meas tran vdout0_2ck1930 FIND v(dout0_2) AT=970.025n

.meas tran vdout0_3ck1930 FIND v(dout0_3) AT=970.025n

.meas tran vdout0_4ck1930 FIND v(dout0_4) AT=970.025n

.meas tran vdout0_5ck1930 FIND v(dout0_5) AT=970.025n

.meas tran vdout0_6ck1930 FIND v(dout0_6) AT=970.025n

.meas tran vdout0_7ck1930 FIND v(dout0_7) AT=970.025n

.meas tran vdout0_8ck1930 FIND v(dout0_8) AT=970.025n

.meas tran vdout0_9ck1930 FIND v(dout0_9) AT=970.025n

.meas tran vdout0_10ck1930 FIND v(dout0_10) AT=970.025n

.meas tran vdout0_11ck1930 FIND v(dout0_11) AT=970.025n

.meas tran vdout0_12ck1930 FIND v(dout0_12) AT=970.025n

.meas tran vdout0_13ck1930 FIND v(dout0_13) AT=970.025n

.meas tran vdout0_14ck1930 FIND v(dout0_14) AT=970.025n

.meas tran vdout0_15ck1930 FIND v(dout0_15) AT=970.025n

.meas tran vdout0_16ck1930 FIND v(dout0_16) AT=970.025n

.meas tran vdout0_17ck1930 FIND v(dout0_17) AT=970.025n

.meas tran vdout0_18ck1930 FIND v(dout0_18) AT=970.025n

.meas tran vdout0_19ck1930 FIND v(dout0_19) AT=970.025n

.meas tran vdout0_20ck1930 FIND v(dout0_20) AT=970.025n

.meas tran vdout0_21ck1930 FIND v(dout0_21) AT=970.025n

.meas tran vdout0_22ck1930 FIND v(dout0_22) AT=970.025n

.meas tran vdout0_23ck1930 FIND v(dout0_23) AT=970.025n

.meas tran vdout0_24ck1930 FIND v(dout0_24) AT=970.025n

.meas tran vdout0_25ck1930 FIND v(dout0_25) AT=970.025n

.meas tran vdout0_26ck1930 FIND v(dout0_26) AT=970.025n

.meas tran vdout0_27ck1930 FIND v(dout0_27) AT=970.025n

.meas tran vdout0_28ck1930 FIND v(dout0_28) AT=970.025n

.meas tran vdout0_29ck1930 FIND v(dout0_29) AT=970.025n

.meas tran vdout0_30ck1930 FIND v(dout0_30) AT=970.025n

.meas tran vdout0_31ck1930 FIND v(dout0_31) AT=970.025n

.meas tran vdout0_0ck2020 FIND v(dout0_0) AT=1015.025n

.meas tran vdout0_1ck2020 FIND v(dout0_1) AT=1015.025n

.meas tran vdout0_2ck2020 FIND v(dout0_2) AT=1015.025n

.meas tran vdout0_3ck2020 FIND v(dout0_3) AT=1015.025n

.meas tran vdout0_4ck2020 FIND v(dout0_4) AT=1015.025n

.meas tran vdout0_5ck2020 FIND v(dout0_5) AT=1015.025n

.meas tran vdout0_6ck2020 FIND v(dout0_6) AT=1015.025n

.meas tran vdout0_7ck2020 FIND v(dout0_7) AT=1015.025n

.meas tran vdout0_8ck2020 FIND v(dout0_8) AT=1015.025n

.meas tran vdout0_9ck2020 FIND v(dout0_9) AT=1015.025n

.meas tran vdout0_10ck2020 FIND v(dout0_10) AT=1015.025n

.meas tran vdout0_11ck2020 FIND v(dout0_11) AT=1015.025n

.meas tran vdout0_12ck2020 FIND v(dout0_12) AT=1015.025n

.meas tran vdout0_13ck2020 FIND v(dout0_13) AT=1015.025n

.meas tran vdout0_14ck2020 FIND v(dout0_14) AT=1015.025n

.meas tran vdout0_15ck2020 FIND v(dout0_15) AT=1015.025n

.meas tran vdout0_16ck2020 FIND v(dout0_16) AT=1015.025n

.meas tran vdout0_17ck2020 FIND v(dout0_17) AT=1015.025n

.meas tran vdout0_18ck2020 FIND v(dout0_18) AT=1015.025n

.meas tran vdout0_19ck2020 FIND v(dout0_19) AT=1015.025n

.meas tran vdout0_20ck2020 FIND v(dout0_20) AT=1015.025n

.meas tran vdout0_21ck2020 FIND v(dout0_21) AT=1015.025n

.meas tran vdout0_22ck2020 FIND v(dout0_22) AT=1015.025n

.meas tran vdout0_23ck2020 FIND v(dout0_23) AT=1015.025n

.meas tran vdout0_24ck2020 FIND v(dout0_24) AT=1015.025n

.meas tran vdout0_25ck2020 FIND v(dout0_25) AT=1015.025n

.meas tran vdout0_26ck2020 FIND v(dout0_26) AT=1015.025n

.meas tran vdout0_27ck2020 FIND v(dout0_27) AT=1015.025n

.meas tran vdout0_28ck2020 FIND v(dout0_28) AT=1015.025n

.meas tran vdout0_29ck2020 FIND v(dout0_29) AT=1015.025n

.meas tran vdout0_30ck2020 FIND v(dout0_30) AT=1015.025n

.meas tran vdout0_31ck2020 FIND v(dout0_31) AT=1015.025n

.meas tran vdout0_0ck2040 FIND v(dout0_0) AT=1025.025n

.meas tran vdout0_1ck2040 FIND v(dout0_1) AT=1025.025n

.meas tran vdout0_2ck2040 FIND v(dout0_2) AT=1025.025n

.meas tran vdout0_3ck2040 FIND v(dout0_3) AT=1025.025n

.meas tran vdout0_4ck2040 FIND v(dout0_4) AT=1025.025n

.meas tran vdout0_5ck2040 FIND v(dout0_5) AT=1025.025n

.meas tran vdout0_6ck2040 FIND v(dout0_6) AT=1025.025n

.meas tran vdout0_7ck2040 FIND v(dout0_7) AT=1025.025n

.meas tran vdout0_8ck2040 FIND v(dout0_8) AT=1025.025n

.meas tran vdout0_9ck2040 FIND v(dout0_9) AT=1025.025n

.meas tran vdout0_10ck2040 FIND v(dout0_10) AT=1025.025n

.meas tran vdout0_11ck2040 FIND v(dout0_11) AT=1025.025n

.meas tran vdout0_12ck2040 FIND v(dout0_12) AT=1025.025n

.meas tran vdout0_13ck2040 FIND v(dout0_13) AT=1025.025n

.meas tran vdout0_14ck2040 FIND v(dout0_14) AT=1025.025n

.meas tran vdout0_15ck2040 FIND v(dout0_15) AT=1025.025n

.meas tran vdout0_16ck2040 FIND v(dout0_16) AT=1025.025n

.meas tran vdout0_17ck2040 FIND v(dout0_17) AT=1025.025n

.meas tran vdout0_18ck2040 FIND v(dout0_18) AT=1025.025n

.meas tran vdout0_19ck2040 FIND v(dout0_19) AT=1025.025n

.meas tran vdout0_20ck2040 FIND v(dout0_20) AT=1025.025n

.meas tran vdout0_21ck2040 FIND v(dout0_21) AT=1025.025n

.meas tran vdout0_22ck2040 FIND v(dout0_22) AT=1025.025n

.meas tran vdout0_23ck2040 FIND v(dout0_23) AT=1025.025n

.meas tran vdout0_24ck2040 FIND v(dout0_24) AT=1025.025n

.meas tran vdout0_25ck2040 FIND v(dout0_25) AT=1025.025n

.meas tran vdout0_26ck2040 FIND v(dout0_26) AT=1025.025n

.meas tran vdout0_27ck2040 FIND v(dout0_27) AT=1025.025n

.meas tran vdout0_28ck2040 FIND v(dout0_28) AT=1025.025n

.meas tran vdout0_29ck2040 FIND v(dout0_29) AT=1025.025n

.meas tran vdout0_30ck2040 FIND v(dout0_30) AT=1025.025n

.meas tran vdout0_31ck2040 FIND v(dout0_31) AT=1025.025n
